* Intel 4004 compatible CPU - PMOS-only full chip, ngspice testbench with a
* Verilog-A (OSDI) MCS-4 memory system supplying program and data
*
* How to run (from the directory holding this file and mcs4mem.va):
*   1. compile the memory model with OpenVAF:
*        openvaf-r mcs4mem.va      (OpenVAF-reloaded -> OSDI 0.4, ngspice >= 44)
*     or openvaf mcs4mem.va        (OpenVAF 23.5     -> OSDI 0.3, ngspice >= 39;
*                                   this route was not tested)
*      -> mcs4mem.osdi
*   2. ngspice -b i4004_pmos_va.cir      (writes i4004_pmos_va.raw)
*      or open it interactively and plot v(rport) v(busval) v(sync)
* To run another program: python3 gen_i4004_pmos.py --asm myprog.asm
* [--stop-at LABEL], then repeat 1-2 (the ROM contents live in mcs4mem.va).
* To run longer than the generated window, raise .param NPER: the Verilog-A
* memory keeps answering the CPU (the expected values listed below stop at
* the end of the generated window).
* Verified with ngspice-47 + OpenVAF-reloaded: ~20 min on one core.

*=============================================================================
*  DEVICE KNOB  -  the only transistor definition in the whole design
*=============================================================================
*  Every transistor in the chip (logic, loads, pass gates, bootstrap capacitors,
*  pad drivers) is an instance of the single subcircuit PFET below.  Swap the
*  p-channel technology by replacing its body; keep the interface:
*
*     .subckt PFET D G S B params: WM=1 LM=1
*        D G S B : drain, gate, source, body (body = VSS = most positive rail;
*                  may be ignored by your model, e.g. a GAA / nanosheet device)
*        WM, LM  : width / length multiples of the unit device WUNIT x LUNIT
*
*  Example with your own model:
*     .subckt PFET D G S B params: WM=1 LM=1
*     X1 D G S B MY_PFET_MODEL W={WM*WUNIT} L={LM*LUNIT}
*     .ends PFET
*  If your device has a fixed L, emulate LM by stacking LM devices in series
*  (only the load devices use LM > 1).
*
*  The default body is a Level-1 card in the spirit of Intel's 1971 10 um
*  silicon-gate PMOS process (VT ~ -1.8 V, tox 120 nm, strong body effect).
*  Design ratios (change together with the device):
*     RATIO : switch width per series level  (switch:load beta ratio
*             = RATIO*LLOAD, 24 by default -> logic-0 level ~ -0.35 V)
*     LLOAD : load-device length multiple (longer = less static power,
*             slower logic-1 edges; defaults give ~0.9 W, original max 1 W)
*-----------------------------------------------------------------------------
.param WUNIT=10u LUNIT=10u LDIF=10u
.param RATIO=2 LLOAD=12 BSW=4 PADW=12

.subckt PFET D G S B params: WM=1 LM=1
M1 D G S B P4004 W={WUNIT*WM} L={LUNIT*LM} AD={WUNIT*WM*LDIF} AS={WUNIT*WM*LDIF}
+ PD={2*WUNIT*WM+2*LDIF} PS={2*WUNIT*WM+2*LDIF}
.ends PFET

.model P4004 PMOS(LEVEL=1 VTO=-1.8 KP=8u GAMMA=0.6 PHI=0.6 LAMBDA=0.02 TOX=120n
+ LD=0.8u CJ=1e-4 MJ=0.5 CJSW=5e-10 MJSW=0.33 PB=0.8 CGSO=2.3e-10 CGDO=2.3e-10
+ CGBO=2e-10)

*=============================================================================
*  I4004P - Intel 4004-compatible CPU, full chip, PMOS-only, transistor level
*=============================================================================
*  3760 p-channel transistors, every one an instance of PFET.
*  Generated by gen_i4004_pmos.py.
*
*  Circuit style of the 1971 original: PMOS ratioed logic with load devices,
*  two-phase dynamic latches (pass transistors clocked directly by PHI1/PHI2,
*  storage on gate capacitance), bootstrapped output drivers, negative logic.
*
*  Subcircuit pins = 4004 DIP pins 1..16:
*    XCPU D0 D1 D2 D3 VSS PHI1 PHI2 SYNC RESET TEST CMROM VDD CMRAM3 CMRAM2
*    +    CMRAM1 CMRAM0 I4004P
*  VSS = 0 V (most positive), VDD = -15 V.  Logic 1 = negative voltage.
*
*  Timing: one clock period = one sub-cycle (PHI1 pulse, then PHI2 pulse);
*  8 periods = 1 instruction cycle A1 A2 A3 M1 M2 X1 X2 X3:
*    A1..A3  CPU sends PC[3:0], PC[7:4], PC[11:8] (PC is incremented one
*            nibble per sub-cycle as it is sent)
*    M1, M2  memory returns OPR, OPA (CPU samples at the end of PHI2)
*    X1..X3  execute; X2 I/O data (write: CPU drives ACC; read: memory drives);
*            SRC sends the register pair at X2 (even) and X3 (odd)
*  Internal state updates during PHI1; inputs are sampled at the end of PHI2.
*  SYNC is active during X3.  CM-ROM and the DCL-selected CM-RAM line(s) are
*  active at A3, at M2 of I/O instructions and at X2 of SRC.
*  RESET (logic 1) clears all registers; the first sub-cycle after it is A1
*  with PC = 0 and CM-RAM0 selected.
*
*  Cells: BSINV 10, DL 1, DLER 132, DLR 10, PAD 10, PAOI22 40, PAOI221 4, PAOI2211 2, PAOI222 12, PAOI2222 22, PAOI222222 8, PAOI3322 1, PCG15 1, PINV 331, PNAND2 112, PNAND3 67, PNOR2 91, PNOR3 11, PNOR4 5, PNOR6 4, PNOR7 1, PNOR8 2
*
*  PFET (and the .params RATIO LLOAD BSW PADW) must be defined first.
*=============================================================================

*----------------------------- logic gates (ratioed PMOS) -----------------
* out = NOT(switch network); a load device pulls Y toward VDD (logic 1),
* conducting switches pull Y to VSS (logic 0).  S = strength multiplier.
.subckt PINV Y A vss vdd params: S=1
XL vdd vdd Y vss PFET WM={S} LM={LLOAD}
XA1 Y A vss vss PFET WM={1*RATIO*S}
.ends PINV
.subckt PNAND3 Y A B C vss vdd params: S=1
XL vdd vdd Y vss PFET WM={S} LM={LLOAD}
XA1 Y A x1 vss PFET WM={3*RATIO*S}
XB2 x1 B x2 vss PFET WM={3*RATIO*S}
XC3 x2 C vss vss PFET WM={3*RATIO*S}
.ends PNAND3
.subckt PAOI22 Y A B C D vss vdd params: S=1
XL vdd vdd Y vss PFET WM={S} LM={LLOAD}
XA1 Y A x1 vss PFET WM={2*RATIO*S}
XB2 x1 B vss vss PFET WM={2*RATIO*S}
XC3 Y C x2 vss PFET WM={2*RATIO*S}
XD4 x2 D vss vss PFET WM={2*RATIO*S}
.ends PAOI22
.subckt PNOR2 Y A B vss vdd params: S=1
XL vdd vdd Y vss PFET WM={S} LM={LLOAD}
XA1 Y A vss vss PFET WM={1*RATIO*S}
XB2 Y B vss vss PFET WM={1*RATIO*S}
.ends PNOR2
.subckt PNAND2 Y A B vss vdd params: S=1
XL vdd vdd Y vss PFET WM={S} LM={LLOAD}
XA1 Y A x1 vss PFET WM={2*RATIO*S}
XB2 x1 B vss vss PFET WM={2*RATIO*S}
.ends PNAND2
.subckt PNOR6 Y A B C D E F vss vdd params: S=1
XL vdd vdd Y vss PFET WM={S} LM={LLOAD}
XA1 Y A vss vss PFET WM={1*RATIO*S}
XB2 Y B vss vss PFET WM={1*RATIO*S}
XC3 Y C vss vss PFET WM={1*RATIO*S}
XD4 Y D vss vss PFET WM={1*RATIO*S}
XE5 Y E vss vss PFET WM={1*RATIO*S}
XF6 Y F vss vss PFET WM={1*RATIO*S}
.ends PNOR6
.subckt PNOR3 Y A B C vss vdd params: S=1
XL vdd vdd Y vss PFET WM={S} LM={LLOAD}
XA1 Y A vss vss PFET WM={1*RATIO*S}
XB2 Y B vss vss PFET WM={1*RATIO*S}
XC3 Y C vss vss PFET WM={1*RATIO*S}
.ends PNOR3
.subckt PAOI222222 Y A B C D E F G H J K L M vss vdd params: S=1
XL vdd vdd Y vss PFET WM={S} LM={LLOAD}
XA1 Y A x1 vss PFET WM={2*RATIO*S}
XB2 x1 B vss vss PFET WM={2*RATIO*S}
XC3 Y C x2 vss PFET WM={2*RATIO*S}
XD4 x2 D vss vss PFET WM={2*RATIO*S}
XE5 Y E x3 vss PFET WM={2*RATIO*S}
XF6 x3 F vss vss PFET WM={2*RATIO*S}
XG7 Y G x4 vss PFET WM={2*RATIO*S}
XH8 x4 H vss vss PFET WM={2*RATIO*S}
XJ9 Y J x5 vss PFET WM={2*RATIO*S}
XK10 x5 K vss vss PFET WM={2*RATIO*S}
XL11 Y L x6 vss PFET WM={2*RATIO*S}
XM12 x6 M vss vss PFET WM={2*RATIO*S}
.ends PAOI222222
.subckt PAOI2222 Y A B C D E F G H vss vdd params: S=1
XL vdd vdd Y vss PFET WM={S} LM={LLOAD}
XA1 Y A x1 vss PFET WM={2*RATIO*S}
XB2 x1 B vss vss PFET WM={2*RATIO*S}
XC3 Y C x2 vss PFET WM={2*RATIO*S}
XD4 x2 D vss vss PFET WM={2*RATIO*S}
XE5 Y E x3 vss PFET WM={2*RATIO*S}
XF6 x3 F vss vss PFET WM={2*RATIO*S}
XG7 Y G x4 vss PFET WM={2*RATIO*S}
XH8 x4 H vss vss PFET WM={2*RATIO*S}
.ends PAOI2222
.subckt PNOR4 Y A B C D vss vdd params: S=1
XL vdd vdd Y vss PFET WM={S} LM={LLOAD}
XA1 Y A vss vss PFET WM={1*RATIO*S}
XB2 Y B vss vss PFET WM={1*RATIO*S}
XC3 Y C vss vss PFET WM={1*RATIO*S}
XD4 Y D vss vss PFET WM={1*RATIO*S}
.ends PNOR4
.subckt PAOI221 Y A B C D E vss vdd params: S=1
XL vdd vdd Y vss PFET WM={S} LM={LLOAD}
XA1 Y A x1 vss PFET WM={2*RATIO*S}
XB2 x1 B vss vss PFET WM={2*RATIO*S}
XC3 Y C x2 vss PFET WM={2*RATIO*S}
XD4 x2 D vss vss PFET WM={2*RATIO*S}
XE5 Y E vss vss PFET WM={2*RATIO*S}
.ends PAOI221
.subckt PAOI2211 Y A B C D E F vss vdd params: S=1
XL vdd vdd Y vss PFET WM={S} LM={LLOAD}
XA1 Y A x1 vss PFET WM={2*RATIO*S}
XB2 x1 B vss vss PFET WM={2*RATIO*S}
XC3 Y C x2 vss PFET WM={2*RATIO*S}
XD4 x2 D vss vss PFET WM={2*RATIO*S}
XE5 Y E vss vss PFET WM={2*RATIO*S}
XF6 Y F vss vss PFET WM={2*RATIO*S}
.ends PAOI2211
.subckt PAOI222 Y A B C D E F vss vdd params: S=1
XL vdd vdd Y vss PFET WM={S} LM={LLOAD}
XA1 Y A x1 vss PFET WM={2*RATIO*S}
XB2 x1 B vss vss PFET WM={2*RATIO*S}
XC3 Y C x2 vss PFET WM={2*RATIO*S}
XD4 x2 D vss vss PFET WM={2*RATIO*S}
XE5 Y E x3 vss PFET WM={2*RATIO*S}
XF6 x3 F vss vss PFET WM={2*RATIO*S}
.ends PAOI222
.subckt PNOR8 Y A B C D E F G H vss vdd params: S=1
XL vdd vdd Y vss PFET WM={S} LM={LLOAD}
XA1 Y A vss vss PFET WM={1*RATIO*S}
XB2 Y B vss vss PFET WM={1*RATIO*S}
XC3 Y C vss vss PFET WM={1*RATIO*S}
XD4 Y D vss vss PFET WM={1*RATIO*S}
XE5 Y E vss vss PFET WM={1*RATIO*S}
XF6 Y F vss vss PFET WM={1*RATIO*S}
XG7 Y G vss vss PFET WM={1*RATIO*S}
XH8 Y H vss vss PFET WM={1*RATIO*S}
.ends PNOR8
.subckt PNOR7 Y A B C D E F G vss vdd params: S=1
XL vdd vdd Y vss PFET WM={S} LM={LLOAD}
XA1 Y A vss vss PFET WM={1*RATIO*S}
XB2 Y B vss vss PFET WM={1*RATIO*S}
XC3 Y C vss vss PFET WM={1*RATIO*S}
XD4 Y D vss vss PFET WM={1*RATIO*S}
XE5 Y E vss vss PFET WM={1*RATIO*S}
XF6 Y F vss vss PFET WM={1*RATIO*S}
XG7 Y G vss vss PFET WM={1*RATIO*S}
.ends PNOR7
.subckt PCG15 Y A B C D vss vdd params: S=1
XL vdd vdd Y vss PFET WM={S} LM={LLOAD}
XA1 Y A x1 vss PFET WM={2*RATIO*S}
XB2 x1 B vss vss PFET WM={2*RATIO*S}
XA3 Y A x2 vss PFET WM={2*RATIO*S}
XC4 x2 C vss vss PFET WM={2*RATIO*S}
XD5 Y D x3 vss PFET WM={2*RATIO*S}
XB6 x3 B vss vss PFET WM={2*RATIO*S}
.ends PCG15
.subckt PAOI3322 Y A B C D E F G H J K vss vdd params: S=1
XL vdd vdd Y vss PFET WM={S} LM={LLOAD}
XA1 Y A x1 vss PFET WM={3*RATIO*S}
XB2 x1 B x2 vss PFET WM={3*RATIO*S}
XC3 x2 C vss vss PFET WM={3*RATIO*S}
XD4 Y D x3 vss PFET WM={3*RATIO*S}
XE5 x3 E x4 vss PFET WM={3*RATIO*S}
XF6 x4 F vss vss PFET WM={3*RATIO*S}
XG7 Y G x5 vss PFET WM={3*RATIO*S}
XH8 x5 H vss vss PFET WM={3*RATIO*S}
XJ9 Y J x6 vss PFET WM={3*RATIO*S}
XK10 x6 K vss vss PFET WM={3*RATIO*S}
.ends PAOI3322
*---------------------------------------------------------------------------
* Dynamic register cells (two-phase, recirculating).  The master node M and
* the slave/output node Q are dynamic: charge on gate capacitance, written
* through PFET pass transistors clocked directly by PHI2 / PHI1.
*   PHI2: M <- DN (input gate)      PHI1: Q <- NOT M      (Q updates on PHI1)
* DLR : Q' = RB & D                         (load every cycle, reset)
* DLER: Q' = RB & (EN ? D : Q)              (load enable, reset)
*---------------------------------------------------------------------------
.subckt DLR Q D RB PHI1 PHI2 vss vdd params: S=1
XL vdd vdd dn vss PFET WM=1 LM={LLOAD}
XA dn RB x1 vss PFET WM={2*RATIO}
XB x1 D vss vss PFET WM={2*RATIO}
XPM dn PHI2 m vss PFET WM=2
XL2 vdd vdd mb vss PFET WM={S} LM={LLOAD}
XS2 mb m vss vss PFET WM={RATIO*S}
XPS mb PHI1 Q vss PFET WM={2*S}
.ends DLR

.subckt DLER Q D EN ENB RB PHI1 PHI2 vss vdd params: S=1
XL vdd vdd dn vss PFET WM=1 LM={LLOAD}
XA dn RB x1 vss PFET WM={3*RATIO}
XB x1 EN x2 vss PFET WM={3*RATIO}
XC x2 D vss vss PFET WM={3*RATIO}
XD x1 ENB x3 vss PFET WM={3*RATIO}
XE x3 Q vss vss PFET WM={3*RATIO}
XPM dn PHI2 m vss PFET WM=2
XL2 vdd vdd mb vss PFET WM={S} LM={LLOAD}
XS2 mb m vss vss PFET WM={RATIO*S}
XPS mb PHI1 Q vss PFET WM={2*S}
.ends DLER

.subckt DL Q D PHI1 PHI2 vss vdd params: S=1
XL vdd vdd dn vss PFET WM=1 LM={LLOAD}
XA dn D vss vss PFET WM={RATIO}
XPM dn PHI2 m vss PFET WM=2
XL2 vdd vdd mb vss PFET WM={S} LM={LLOAD}
XS2 mb m vss vss PFET WM={RATIO*S}
XPS mb PHI1 Q vss PFET WM={2*S}
.ends DL

*---------------------------------------------------------------------------
* BSINV: bootstrapped inverter (Faggin's bootstrap load).  XI precharges G
* to about VDD+|VT|; when Y falls, the MOS capacitor XC pushes G below VDD so
* the load XL stays fully on and Y reaches the full VDD level.
*---------------------------------------------------------------------------
.subckt BSINV Y A vss vdd
XS Y A vss vss PFET WM={BSW*RATIO}
XL vdd G Y vss PFET WM=1 LM=2
XI vdd vdd G vss PFET WM=1
XC Y G Y vss PFET WM=4 LM=4
.ends BSINV

*---------------------------------------------------------------------------
* PADDRV: push-pull PMOS output stage.  G1 (logic 1) pulls PAD to VSS
* (logic 0); G2 (logic 1, bootstrapped) pulls PAD toward VDD (logic 1).
*---------------------------------------------------------------------------
.subckt PADDRV PAD G1 G2 vss vdd
XT1 PAD G1 vss vss PFET WM={PADW}
XT2 PAD G2 vdd vss PFET WM={PADW}
.ends PADDRV

*----------------------------- the chip ------------------------------------
.subckt I4004P d0 d1 d2 d3 vss phi1 phi2 sync reset test cmrom vdd cmram3 cmram2 cmram1 cmram0
* ---- input receivers (RESET, TEST, data bus)
XG1 rb reset vss vdd PINV
XG2 n1 rb_b0 vss vdd PINV
XG3 ntest test vss vdd PINV
XG4 n2 d0 vss vdd PINV
XG5 bi0 n2 vss vdd PINV S=3
XG6 n3 d1 vss vdd PINV
XG7 bi1 n3 vss vdd PINV S=3
XG8 n4 d2 vss vdd PINV
XG9 bi2 n4 vss vdd PINV S=3
XG10 n5 d3 vss vdd PINV
XG11 bi3 n5 vss vdd PINV S=3
* ---- timing generator: 3-bit Gray counter A1 A2 A3 M1 M2 X1 X2 X3
XG12 n6 t2 vss vdd PINV S=3
XG13 n7 t1 vss vdd PINV S=3
XG14 n8 t0 vss vdd PINV S=3
XG15 n9 n6 n7 n8 vss vdd PNAND3
XG16 s_a1 n9 vss vdd PINV S=3
XG17 n10 n6 n7 t0 vss vdd PNAND3
XG18 s_a2 n10 vss vdd PINV S=3
XG19 n11 n6 t1 t0 vss vdd PNAND3
XG20 s_a3 n11 vss vdd PINV S=3
XG21 n12 n6 t1 n8 vss vdd PNAND3
XG22 s_m1 n12 vss vdd PINV S=2
XG23 n13 t2 t1 n8 vss vdd PNAND3
XG24 s_m2 n13 vss vdd PINV
XG25 n14 t2 t1 t0 vss vdd PNAND3
XG26 s_x1 n14 vss vdd PINV S=6
XG27 n15 t2 n7 t0 vss vdd PNAND3
XG28 s_x2 n15 vss vdd PINV S=3
XG29 n16 t2 n7 n8 vss vdd PNAND3
XG30 s_x3 n16 vss vdd PINV S=2
XG31 n17 n7 t2 t1 n6 vss vdd PAOI22
Xr_t0 t0 n17 rb_b0 phi1 phi2 vss vdd DLR S=4
XG32 n18 n8 t1 t0 n6 vss vdd PAOI22
XG33 n19 n18 vss vdd PINV
Xr_t1 t1 n19 rb_b0 phi1 phi2 vss vdd DLR S=4
XG34 n20 n8 t1 t0 t2 vss vdd PAOI22
XG35 n21 n20 vss vdd PINV
Xr_t2 t2 n21 rb_b0 phi1 phi2 vss vdd DLR S=4
* ---- instruction decoder
XG36 n22 opr1 vss vdd PINV S=3
XG37 n23 opr2 vss vdd PINV S=3
XG38 n24 opr3 vss vdd PINV S=5
XG39 n25 opr0 n22 n23 vss vdd PNAND3
XG40 n26 n24 vss vdd PINV S=2
XG41 i_jcn n25 n26 vss vdd PNOR2
XG42 n27 opr0 vss vdd PINV S=2
XG43 n28 n27 opr1 n23 vss vdd PNAND3
XG44 n29 n26 n28 vss vdd PNOR2
XG45 n30 opr0 opr1 n23 vss vdd PNAND3
XG46 n31 n26 n30 vss vdd PNOR2
XG47 n32 n27 n22 opr2 vss vdd PNAND3
XG48 i_jun n26 n32 vss vdd PNOR2
XG49 n33 opr0 n22 opr2 vss vdd PNAND3
XG50 i_jms n26 n33 vss vdd PNOR2
XG51 n34 n27 opr1 opr2 vss vdd PNAND3
XG52 i_inc n26 n34 vss vdd PNOR2
XG53 n35 opr0 opr1 opr2 vss vdd PNAND3 S=2
XG54 i_isz n26 n35 vss vdd PNOR2
XG55 n36 n27 n22 n23 vss vdd PNAND3
XG56 i_add n24 n36 vss vdd PNOR2
XG57 i_sub n24 n25 vss vdd PNOR2
XG58 i_ld n24 n28 vss vdd PNOR2
XG59 i_xch n24 n30 vss vdd PNOR2
XG60 i_bbl n24 n32 vss vdd PNOR2
XG61 i_ldm n24 n33 vss vdd PNOR2
XG62 i_io n24 n34 vss vdd PNOR2 S=2
XG63 i_acc n24 n35 vss vdd PNOR2 S=6
XG64 n37 opa0 vss vdd PINV S=3
XG65 n38 opa1 vss vdd PINV S=4
XG66 n39 opa2 vss vdd PINV S=4
XG67 n40 opa3 vss vdd PINV S=5
XG68 n41 n37 n38 n39 vss vdd PNAND3
XG69 n42 n40 vss vdd PINV S=2
XG70 n43 n41 n42 vss vdd PNOR2
XG71 n44 opa0 n38 n39 vss vdd PNAND3
XG72 n45 n42 n44 vss vdd PNOR2
XG73 n46 n37 opa1 n39 vss vdd PNAND3
XG74 n47 n42 n46 vss vdd PNOR2
XG75 n48 opa0 opa1 n39 vss vdd PNAND3
XG76 n49 n42 n48 vss vdd PNOR2
XG77 n50 n37 n38 opa2 vss vdd PNAND3
XG78 n51 n42 n50 vss vdd PNOR2
XG79 n52 opa0 n38 opa2 vss vdd PNAND3
XG80 n53 n42 n52 vss vdd PNOR2
XG81 n54 n37 opa1 opa2 vss vdd PNAND3
XG82 n55 n42 n54 vss vdd PNOR2
XG83 n56 opa0 opa1 opa2 vss vdd PNAND3
XG84 n57 n42 n56 vss vdd PNOR2
XG85 n58 n40 n41 vss vdd PNOR2
XG86 n59 n40 n44 vss vdd PNOR2
XG87 n60 n40 n46 vss vdd PNOR2
XG88 n61 n40 n48 vss vdd PNOR2
XG89 n62 n40 n50 vss vdd PNOR2
XG90 n63 n40 n52 vss vdd PNOR2
XG91 n64 n40 n54 vss vdd PNOR2
XG92 n65 n40 n56 vss vdd PNOR2
XG93 n66 n24 n23 opr1 vss vdd PNAND3
XG94 i_pair n66 vss vdd PINV
XG95 n67 n29 n37 vss vdd PNAND2
XG96 i_fim n67 vss vdd PINV
XG97 n68 n29 opa0 vss vdd PNAND2
XG98 i_src n68 vss vdd PINV S=2
XG99 n69 n31 n37 vss vdd PNAND2
XG100 i_fin n69 vss vdd PINV
XG101 n70 n31 opa0 vss vdd PNAND2
XG102 i_jin n70 vss vdd PINV
XG103 n71 n24 opr2 n22 vss vdd PNAND3
XG104 i_jj n71 vss vdd PINV
XG105 n72 i_io n40 vss vdd PNAND2
XG106 i_iow n72 vss vdd PINV
XG107 n73 i_io opa3 vss vdd PNAND2
XG108 i_ior n73 vss vdd PINV
XG109 n74 i_io n58 vss vdd PNAND2
XG110 n75 n74 vss vdd PINV
XG111 n76 i_io n61 vss vdd PNAND2
XG112 n77 n76 vss vdd PINV
XG113 n78 n59 n60 n62 n63 n64 n65 vss vdd PNOR6
XG114 n79 n78 vss vdd PINV
XG115 n80 i_io n79 vss vdd PNAND2
XG116 n81 n80 vss vdd PINV S=2
XG117 n82 i_acc n43 vss vdd PNAND2
XG118 n83 n82 vss vdd PINV
XG119 n84 i_acc n45 vss vdd PNAND2
XG120 n85 n84 vss vdd PINV
XG121 n86 i_acc n47 vss vdd PNAND2
XG122 n87 n86 vss vdd PINV
XG123 n88 i_acc n49 vss vdd PNAND2
XG124 n89 n88 vss vdd PINV
XG125 n90 i_acc n51 vss vdd PNAND2
XG126 n91 n90 vss vdd PINV S=2
XG127 n92 i_acc n53 vss vdd PNAND2
XG128 n93 n92 vss vdd PINV S=2
XG129 n94 i_acc n55 vss vdd PNAND2
XG130 n95 n94 vss vdd PINV S=2
XG131 n96 i_acc n57 vss vdd PNAND2
XG132 n97 n96 vss vdd PINV
XG133 n98 i_acc n58 vss vdd PNAND2
XG134 n99 n98 vss vdd PINV S=2
XG135 n100 i_acc n59 vss vdd PNAND2
XG136 n101 n100 vss vdd PINV
XG137 n102 i_acc n60 vss vdd PNAND2
XG138 n103 n102 vss vdd PINV
XG139 n104 i_acc n61 vss vdd PNAND2
XG140 n105 n104 vss vdd PINV S=2
XG141 n106 i_acc n62 vss vdd PNAND2
XG142 n107 n106 vss vdd PINV S=2
XG143 n108 i_acc n63 vss vdd PNAND2
XG144 n109 n108 vss vdd PINV
XG145 ndc dc vss vdd PINV
XG146 n110 dc i_fin vss vdd PNAND2
XG147 fin2 n110 vss vdd PINV S=2
XG148 n111 fin2 vss vdd PINV S=3
XG149 n112 i_fim i_fin i_isz i_jcn i_jms i_jun vss vdd PNOR6
XG150 n113 n112 vss vdd PINV
* ---- instruction register OPR/OPA, double-cycle flag, JCN condition latch
XG151 n114 ndc_b0 s_m1 vss vdd PNAND2
XG152 en_opr n114 vss vdd PINV S=3
XG153 n115 ndc_b0 s_m2 vss vdd PNAND2
XG154 en_opa n115 vss vdd PINV S=3
XG155 n116 en_opr vss vdd PINV S=2
Xr_opr0 opr0 bi0 en_opr n116 rb_b0 phi1 phi2 vss vdd DLER S=4
XG156 n117 en_opa vss vdd PINV S=2
Xr_opa0 opa0 bi0 en_opa n117 rb_b0 phi1 phi2 vss vdd DLER S=6
Xr_opr1 opr1 bi1 en_opr n116 rb_b0 phi1 phi2 vss vdd DLER S=4
Xr_opa1 opa1 bi1 en_opa n117 rb_b0 phi1 phi2 vss vdd DLER S=6
Xr_opr2 opr2 bi2 en_opr n116 rb_b1 phi1 phi2 vss vdd DLER S=4
Xr_opa2 opa2 bi2 en_opa n117 rb_b1 phi1 phi2 vss vdd DLER S=6
Xr_opr3 opr3 bi3 en_opr n116 rb_b1 phi1 phi2 vss vdd DLER S=3
Xr_opa3 opa3 bi3 en_opa n117 rb_b1 phi1 phi2 vss vdd DLER S=5
XG157 n118 ndc_b0 n113 vss vdd PNAND2
XG158 n119 n118 vss vdd PINV
XG159 n120 s_x3 vss vdd PINV
Xr_dc dc n119 s_x3 n120 rb_b1 phi1 phi2 vss vdd DLER S=6
* ---- index register array 16 x 4 (1 read / 1 write port)
XG160 n121 i_pair vss vdd PINV
XG161 n122 i_pair s_x3 n121 opa0 vss vdd PAOI22
XG162 n123 n122 vss vdd PINV
XG163 n124 fin2 s_a1 n111 n123 vss vdd PAOI22
XG164 ra0 n124 vss vdd PINV S=2
XG165 n125 opa1 n111 vss vdd PNAND2
XG166 ra1 n125 vss vdd PINV S=2
XG167 n126 opa2 n111 vss vdd PNAND2
XG168 ra2 n126 vss vdd PINV S=2
XG169 n127 opa3 n111 vss vdd PNAND2
XG170 ra3 n127 vss vdd PINV S=2
XG171 n128 dc vss vdd PINV S=2
XG172 n129 dc s_m2 n128 opa0 vss vdd PAOI22
XG173 wa0 n129 vss vdd PINV S=2
XG174 n130 i_inc i_isz i_xch vss vdd PNOR3
XG175 n131 n130 vss vdd PINV
XG176 n132 ndc_b0 s_x1 n131 vss vdd PNAND3
XG177 n133 n132 vss vdd PINV
XG178 n134 s_m1 s_m2 vss vdd PNOR2
XG179 n135 n134 vss vdd PINV S=3
XG180 n136 i_fim i_fin vss vdd PNOR2
XG181 n137 n136 vss vdd PINV
XG182 n138 dc n135 n137 vss vdd PNAND3
XG183 n139 n138 vss vdd PINV
XG184 n140 n133 n139 vss vdd PNOR2
XG185 rf_we n140 vss vdd PINV S=4
XG186 n141 rd0 vss vdd PINV
XG187 n142 rd1 vss vdd PINV
XG188 n143 n142 n141 rd1 rd0 vss vdd PAOI22
XG189 n144 rd1 rd0 vss vdd PNAND2
XG190 n145 n144 vss vdd PINV
XG191 n146 rd2 vss vdd PINV
XG192 n147 n146 n144 rd2 n145 vss vdd PAOI22
XG193 n148 rd2 n145 vss vdd PNAND2
XG194 n149 n148 vss vdd PINV
XG195 n150 rd3 vss vdd PINV
XG196 n151 n150 n148 rd3 n149 vss vdd PAOI22
XG197 n152 rd3 n149 vss vdd PNAND2
XG198 n153 n152 vss vdd PINV
XG199 n154 n24 n141 opr3 acc0 vss vdd PAOI22
XG200 n155 n154 vss vdd PINV
XG201 n156 dc bi0 n128 n155 vss vdd PAOI22
XG202 rf_wd0 n156 vss vdd PINV
XG203 n157 n24 n143 opr3 acc1 vss vdd PAOI22
XG204 n158 n157 vss vdd PINV
XG205 n159 dc bi1 n128 n158 vss vdd PAOI22
XG206 rf_wd1 n159 vss vdd PINV
XG207 n160 n24 n147 opr3 acc2 vss vdd PAOI22
XG208 n161 n160 vss vdd PINV
XG209 n162 dc bi2 n128 n161 vss vdd PAOI22
XG210 rf_wd2 n162 vss vdd PINV
XG211 n163 n24 n151 opr3 acc3 vss vdd PAOI22
XG212 n164 n163 vss vdd PINV
XG213 n165 dc bi3 n128 n164 vss vdd PAOI22
XG214 rf_wd3 n165 vss vdd PINV
XG215 n166 ra1 vss vdd PINV S=2
XG216 n167 ra0 vss vdd PINV S=2
XG217 n168 n166 n167 vss vdd PNAND2 S=2
XG218 n169 n166 ra0 vss vdd PNAND2 S=2
XG219 n170 ra1 n167 vss vdd PNAND2 S=2
XG220 n171 ra1 ra0 vss vdd PNAND2 S=2
XG221 n172 ra3 vss vdd PINV S=2
XG222 n173 ra2 vss vdd PINV S=2
XG223 n174 n172 n173 vss vdd PNAND2 S=2
XG224 n175 n172 ra2 vss vdd PNAND2 S=2
XG225 n176 ra3 n173 vss vdd PNAND2 S=2
XG226 n177 ra3 ra2 vss vdd PNAND2 S=2
XG227 rsel0 n168 n174 vss vdd PNOR2 S=3
XG228 rsel1 n169 n174 vss vdd PNOR2 S=3
XG229 rsel2 n170 n174 vss vdd PNOR2 S=3
XG230 rsel3 n171 n174 vss vdd PNOR2 S=3
XG231 rsel4 n168 n175 vss vdd PNOR2 S=3
XG232 rsel5 n169 n175 vss vdd PNOR2 S=3
XG233 rsel6 n170 n175 vss vdd PNOR2 S=3
XG234 rsel7 n171 n175 vss vdd PNOR2 S=3
XG235 rsel8 n168 n176 vss vdd PNOR2 S=3
XG236 rsel9 n169 n176 vss vdd PNOR2 S=3
XG237 rsel10 n170 n176 vss vdd PNOR2 S=3
XG238 rsel11 n171 n176 vss vdd PNOR2 S=3
XG239 rsel12 n168 n177 vss vdd PNOR2 S=3
XG240 rsel13 n169 n177 vss vdd PNOR2 S=3
XG241 rsel14 n170 n177 vss vdd PNOR2 S=3
XG242 rsel15 n171 n177 vss vdd PNOR2 S=3
XG243 n178 wa0 vss vdd PINV S=2
XG244 n179 n38 n178 vss vdd PNAND2 S=2
XG245 n180 n38 wa0 vss vdd PNAND2 S=2
XG246 n181 opa1 n178 vss vdd PNAND2 S=2
XG247 n182 opa1 wa0 vss vdd PNAND2 S=2
XG248 n183 rf_we n40 n39 vss vdd PNAND3 S=2
XG249 n184 rf_we n40 opa2 vss vdd PNAND3 S=2
XG250 n185 rf_we opa3 n39 vss vdd PNAND3 S=2
XG251 n186 rf_we opa3 opa2 vss vdd PNAND3 S=2
XG252 wen0 n179 n183 vss vdd PNOR2 S=3
XG253 n187 wen0 vss vdd PINV S=2
Xr0_0 r0_0 rf_wd0_b0 wen0 n187 rb_b1 phi1 phi2 vss vdd DLER S=2
Xr0_1 r0_1 rf_wd1_b0 wen0 n187 rb_b1 phi1 phi2 vss vdd DLER S=2
Xr0_2 r0_2 rf_wd2_b0 wen0 n187 rb_b2 phi1 phi2 vss vdd DLER S=2
Xr0_3 r0_3 rf_wd3_b0 wen0 n187 rb_b2 phi1 phi2 vss vdd DLER S=2
XG254 wen1 n180 n183 vss vdd PNOR2 S=3
XG255 n188 wen1 vss vdd PINV S=2
Xr1_0 r1_0 rf_wd0_b0 wen1 n188 rb_b2 phi1 phi2 vss vdd DLER S=2
Xr1_1 r1_1 rf_wd1_b0 wen1 n188 rb_b2 phi1 phi2 vss vdd DLER S=2
Xr1_2 r1_2 rf_wd2_b0 wen1 n188 rb_b2 phi1 phi2 vss vdd DLER S=2
Xr1_3 r1_3 rf_wd3_b0 wen1 n188 rb_b2 phi1 phi2 vss vdd DLER S=2
XG256 wen2 n181 n183 vss vdd PNOR2 S=3
XG257 n189 wen2 vss vdd PINV S=2
Xr2_0 r2_0 rf_wd0_b0 wen2 n189 rb_b2 phi1 phi2 vss vdd DLER S=2
Xr2_1 r2_1 rf_wd1_b0 wen2 n189 rb_b3 phi1 phi2 vss vdd DLER S=2
Xr2_2 r2_2 rf_wd2_b0 wen2 n189 rb_b3 phi1 phi2 vss vdd DLER S=2
Xr2_3 r2_3 rf_wd3_b0 wen2 n189 rb_b3 phi1 phi2 vss vdd DLER S=2
XG258 wen3 n182 n183 vss vdd PNOR2 S=3
XG259 n190 wen3 vss vdd PINV S=2
Xr3_0 r3_0 rf_wd0_b0 wen3 n190 rb_b3 phi1 phi2 vss vdd DLER S=2
Xr3_1 r3_1 rf_wd1_b0 wen3 n190 rb_b3 phi1 phi2 vss vdd DLER S=2
Xr3_2 r3_2 rf_wd2_b0 wen3 n190 rb_b3 phi1 phi2 vss vdd DLER S=2
Xr3_3 r3_3 rf_wd3_b0 wen3 n190 rb_b3 phi1 phi2 vss vdd DLER S=2
XG260 wen4 n179 n184 vss vdd PNOR2 S=3
XG261 n191 wen4 vss vdd PINV S=2
Xr4_0 r4_0 rf_wd0_b0 wen4 n191 rb_b4 phi1 phi2 vss vdd DLER S=2
Xr4_1 r4_1 rf_wd1_b0 wen4 n191 rb_b4 phi1 phi2 vss vdd DLER S=2
Xr4_2 r4_2 rf_wd2_b0 wen4 n191 rb_b4 phi1 phi2 vss vdd DLER S=2
Xr4_3 r4_3 rf_wd3_b0 wen4 n191 rb_b4 phi1 phi2 vss vdd DLER S=2
XG262 wen5 n180 n184 vss vdd PNOR2 S=3
XG263 n192 wen5 vss vdd PINV S=2
Xr5_0 r5_0 rf_wd0_b0 wen5 n192 rb_b4 phi1 phi2 vss vdd DLER S=2
Xr5_1 r5_1 rf_wd1_b0 wen5 n192 rb_b4 phi1 phi2 vss vdd DLER S=2
Xr5_2 r5_2 rf_wd2_b0 wen5 n192 rb_b4 phi1 phi2 vss vdd DLER S=2
Xr5_3 r5_3 rf_wd3_b0 wen5 n192 rb_b5 phi1 phi2 vss vdd DLER S=2
XG264 wen6 n181 n184 vss vdd PNOR2 S=3
XG265 n193 wen6 vss vdd PINV S=2
Xr6_0 r6_0 rf_wd0_b0 wen6 n193 rb_b5 phi1 phi2 vss vdd DLER S=2
Xr6_1 r6_1 rf_wd1_b0 wen6 n193 rb_b5 phi1 phi2 vss vdd DLER S=2
Xr6_2 r6_2 rf_wd2_b0 wen6 n193 rb_b5 phi1 phi2 vss vdd DLER S=2
Xr6_3 r6_3 rf_wd3_b0 wen6 n193 rb_b5 phi1 phi2 vss vdd DLER S=2
XG266 wen7 n182 n184 vss vdd PNOR2 S=3
XG267 n194 wen7 vss vdd PINV S=2
Xr7_0 r7_0 rf_wd0_b1 wen7 n194 rb_b5 phi1 phi2 vss vdd DLER S=2
Xr7_1 r7_1 rf_wd1_b1 wen7 n194 rb_b5 phi1 phi2 vss vdd DLER S=2
Xr7_2 r7_2 rf_wd2_b1 wen7 n194 rb_b6 phi1 phi2 vss vdd DLER S=2
Xr7_3 r7_3 rf_wd3_b1 wen7 n194 rb_b6 phi1 phi2 vss vdd DLER S=2
XG268 wen8 n179 n185 vss vdd PNOR2 S=3
XG269 n195 wen8 vss vdd PINV S=2
Xr8_0 r8_0 rf_wd0_b1 wen8 n195 rb_b6 phi1 phi2 vss vdd DLER S=2
Xr8_1 r8_1 rf_wd1_b1 wen8 n195 rb_b6 phi1 phi2 vss vdd DLER S=2
Xr8_2 r8_2 rf_wd2_b1 wen8 n195 rb_b6 phi1 phi2 vss vdd DLER S=2
Xr8_3 r8_3 rf_wd3_b1 wen8 n195 rb_b6 phi1 phi2 vss vdd DLER S=2
XG270 wen9 n180 n185 vss vdd PNOR2 S=3
XG271 n196 wen9 vss vdd PINV S=2
Xr9_0 r9_0 rf_wd0_b1 wen9 n196 rb_b6 phi1 phi2 vss vdd DLER S=2
Xr9_1 r9_1 rf_wd1_b1 wen9 n196 rb_b7 phi1 phi2 vss vdd DLER S=2
Xr9_2 r9_2 rf_wd2_b1 wen9 n196 rb_b7 phi1 phi2 vss vdd DLER S=2
Xr9_3 r9_3 rf_wd3_b1 wen9 n196 rb_b7 phi1 phi2 vss vdd DLER S=2
XG272 wen10 n181 n185 vss vdd PNOR2 S=3
XG273 n197 wen10 vss vdd PINV S=2
Xr10_0 r10_0 rf_wd0_b1 wen10 n197 rb_b7 phi1 phi2 vss vdd DLER S=2
Xr10_1 r10_1 rf_wd1_b1 wen10 n197 rb_b7 phi1 phi2 vss vdd DLER S=2
Xr10_2 r10_2 rf_wd2_b1 wen10 n197 rb_b7 phi1 phi2 vss vdd DLER S=2
Xr10_3 r10_3 rf_wd3_b1 wen10 n197 rb_b7 phi1 phi2 vss vdd DLER S=2
XG274 wen11 n182 n185 vss vdd PNOR2 S=3
XG275 n198 wen11 vss vdd PINV S=2
Xr11_0 r11_0 rf_wd0_b1 wen11 n198 rb_b8 phi1 phi2 vss vdd DLER S=2
Xr11_1 r11_1 rf_wd1_b1 wen11 n198 rb_b8 phi1 phi2 vss vdd DLER S=2
Xr11_2 r11_2 rf_wd2_b1 wen11 n198 rb_b8 phi1 phi2 vss vdd DLER S=2
Xr11_3 r11_3 rf_wd3_b1 wen11 n198 rb_b8 phi1 phi2 vss vdd DLER S=2
XG276 wen12 n179 n186 vss vdd PNOR2 S=3
XG277 n199 wen12 vss vdd PINV S=2
Xr12_0 r12_0 rf_wd0_b1 wen12 n199 rb_b8 phi1 phi2 vss vdd DLER S=2
Xr12_1 r12_1 rf_wd1_b1 wen12 n199 rb_b8 phi1 phi2 vss vdd DLER S=2
Xr12_2 r12_2 rf_wd2_b1 wen12 n199 rb_b8 phi1 phi2 vss vdd DLER S=2
Xr12_3 r12_3 rf_wd3_b1 wen12 n199 rb_b9 phi1 phi2 vss vdd DLER S=2
XG278 wen13 n180 n186 vss vdd PNOR2 S=3
XG279 n200 wen13 vss vdd PINV S=2
Xr13_0 r13_0 rf_wd0_b1 wen13 n200 rb_b9 phi1 phi2 vss vdd DLER S=2
Xr13_1 r13_1 rf_wd1_b1 wen13 n200 rb_b9 phi1 phi2 vss vdd DLER S=2
Xr13_2 r13_2 rf_wd2_b1 wen13 n200 rb_b9 phi1 phi2 vss vdd DLER S=2
Xr13_3 r13_3 rf_wd3_b1 wen13 n200 rb_b9 phi1 phi2 vss vdd DLER S=2
XG280 wen14 n181 n186 vss vdd PNOR2 S=3
XG281 n201 wen14 vss vdd PINV S=2
Xr14_0 r14_0 rf_wd0_b2 wen14 n201 rb_b9 phi1 phi2 vss vdd DLER S=2
Xr14_1 r14_1 rf_wd1_b2 wen14 n201 rb_b9 phi1 phi2 vss vdd DLER S=2
Xr14_2 r14_2 rf_wd2_b2 wen14 n201 rb_b10 phi1 phi2 vss vdd DLER S=2
Xr14_3 r14_3 rf_wd3_b2 wen14 n201 rb_b10 phi1 phi2 vss vdd DLER S=2
XG282 wen15 n182 n186 vss vdd PNOR2 S=3
XG283 n202 wen15 vss vdd PINV S=2
Xr15_0 r15_0 rf_wd0_b2 wen15 n202 rb_b10 phi1 phi2 vss vdd DLER S=2
Xr15_1 r15_1 rf_wd1_b2 wen15 n202 rb_b10 phi1 phi2 vss vdd DLER S=2
Xr15_2 r15_2 rf_wd2_b2 wen15 n202 rb_b10 phi1 phi2 vss vdd DLER S=2
Xr15_3 r15_3 rf_wd3_b2 wen15 n202 rb_b10 phi1 phi2 vss vdd DLER S=2
XG284 n203 rsel0 r0_0 rsel1 r1_0 rsel2 r2_0 rsel3 r3_0 rsel4 r4_0 rsel5 r5_0 vss vdd PAOI222222 S=2
XG285 n204 rsel10 r10_0 rsel11 r11_0 rsel6 r6_0 rsel7 r7_0 rsel8 r8_0 rsel9 r9_0 vss vdd PAOI222222
+ S=2
XG286 n205 rsel12 r12_0 rsel13 r13_0 rsel14 r14_0 rsel15 r15_0 vss vdd PAOI2222 S=2
XG287 rd0 n203 n204 n205 vss vdd PNAND3 S=3
XG288 n206 rsel0 r0_1 rsel1 r1_1 rsel2 r2_1 rsel3 r3_1 rsel4 r4_1 rsel5 r5_1 vss vdd PAOI222222 S=2
XG289 n207 rsel10 r10_1 rsel11 r11_1 rsel6 r6_1 rsel7 r7_1 rsel8 r8_1 rsel9 r9_1 vss vdd PAOI222222
+ S=2
XG290 n208 rsel12 r12_1 rsel13 r13_1 rsel14 r14_1 rsel15 r15_1 vss vdd PAOI2222 S=2
XG291 rd1 n206 n207 n208 vss vdd PNAND3 S=3
XG292 n209 rsel0 r0_2 rsel1 r1_2 rsel2 r2_2 rsel3 r3_2 rsel4 r4_2 rsel5 r5_2 vss vdd PAOI222222 S=2
XG293 n210 rsel10 r10_2 rsel11 r11_2 rsel6 r6_2 rsel7 r7_2 rsel8 r8_2 rsel9 r9_2 vss vdd PAOI222222
+ S=2
XG294 n211 rsel12 r12_2 rsel13 r13_2 rsel14 r14_2 rsel15 r15_2 vss vdd PAOI2222 S=2
XG295 rd2 n209 n210 n211 vss vdd PNAND3 S=3
XG296 n212 rsel0 r0_3 rsel1 r1_3 rsel2 r2_3 rsel3 r3_3 rsel4 r4_3 rsel5 r5_3 vss vdd PAOI222222 S=2
XG297 n213 rsel10 r10_3 rsel11 r11_3 rsel6 r6_3 rsel7 r7_3 rsel8 r8_3 rsel9 r9_3 vss vdd PAOI222222
+ S=2
XG298 n214 rsel12 r12_3 rsel13 r13_3 rsel14 r14_3 rsel15 r15_3 vss vdd PAOI2222 S=2
XG299 rd3 n212 n213 n214 vss vdd PNAND3 S=3
* ---- ALU, accumulator, carry
XG300 n215 i_add i_sub vss vdd PNOR2
XG301 n216 n215 vss vdd PINV S=2
XG302 n217 n75 n77 vss vdd PNOR2
XG303 n218 n217 vss vdd PINV S=2
XG304 n219 i_sub n75 vss vdd PNOR2
XG305 alu_sub n219 vss vdd PINV S=2
XG306 n220 i_add i_sub n75 n77 vss vdd PNOR4
XG307 n221 n220 vss vdd PINV
XG308 n222 acc1 acc2 vss vdd PNOR2
XG309 n223 n222 vss vdd PINV
XG310 n224 acc3 n223 vss vdd PNAND2
XG311 n225 n224 vss vdd PINV
XG312 n226 cy n225 vss vdd PNOR2
XG313 n227 n226 vss vdd PINV
XG314 n228 n105 n227 vss vdd PNAND2
XG315 daa_adj n228 vss vdd PINV
XG316 n229 n216 rd0 n218 bi0 n99 vss vdd PAOI221
XG317 n230 n229 vss vdd PINV
XG318 n231 alu_sub vss vdd PINV S=2
XG319 n232 n229 n231 n230 alu_sub vss vdd PAOI22
XG320 n233 n216 rd1 n218 bi1 daa_adj n99 vss vdd PAOI2211
XG321 n234 n233 vss vdd PINV
XG322 n235 n233 n231 n234 alu_sub vss vdd PAOI22
XG323 n236 n216 rd2 n218 bi2 daa_adj n99 vss vdd PAOI2211
XG324 n237 n236 vss vdd PINV
XG325 n238 n236 n231 n237 alu_sub vss vdd PAOI22
XG326 n239 n216 rd3 n218 bi3 n99 vss vdd PAOI221
XG327 n240 n239 vss vdd PINV
XG328 n241 n239 n231 n240 alu_sub vss vdd PAOI22
XG329 n242 cy vss vdd PINV
XG330 n243 cy alu_sub n242 n231 vss vdd PAOI22
XG331 n244 n221 n243 vss vdd PNAND2
XG332 n245 n244 vss vdd PINV
XG333 n246 n245 n87 vss vdd PNOR2
XG334 alu_cin n246 vss vdd PINV
XG335 n247 acc0 vss vdd PINV
XG336 n248 n232 vss vdd PINV
XG337 n249 acc0 n232 n247 n248 vss vdd PAOI22
XG338 n250 n249 vss vdd PINV
XG339 n251 alu_cin vss vdd PINV
XG340 alu_s0 n249 alu_cin n250 n251 vss vdd PAOI22
XG341 n252 acc0 n232 vss vdd PNAND2
XG342 n253 n249 alu_cin vss vdd PNAND2
XG343 alu_c1 n252 n253 vss vdd PNAND2
XG344 n254 acc1 vss vdd PINV
XG345 n255 n235 vss vdd PINV
XG346 n256 acc1 n235 n254 n255 vss vdd PAOI22
XG347 n257 n256 vss vdd PINV
XG348 n258 alu_c1 vss vdd PINV
XG349 alu_s1 n256 alu_c1 n257 n258 vss vdd PAOI22
XG350 n259 acc1 n235 vss vdd PNAND2
XG351 n260 n256 alu_c1 vss vdd PNAND2
XG352 alu_c2 n259 n260 vss vdd PNAND2
XG353 n261 acc2 vss vdd PINV
XG354 n262 n238 vss vdd PINV
XG355 n263 acc2 n238 n261 n262 vss vdd PAOI22
XG356 n264 n263 vss vdd PINV
XG357 n265 alu_c2 vss vdd PINV
XG358 alu_s2 n263 alu_c2 n264 n265 vss vdd PAOI22
XG359 n266 acc2 n238 vss vdd PNAND2
XG360 n267 n263 alu_c2 vss vdd PNAND2
XG361 alu_c3 n266 n267 vss vdd PNAND2
XG362 n268 acc3 vss vdd PINV
XG363 n269 n241 vss vdd PINV
XG364 n270 acc3 n241 n268 n269 vss vdd PAOI22
XG365 n271 n270 vss vdd PINV
XG366 n272 alu_c3 vss vdd PINV
XG367 alu_s3 n270 alu_c3 n271 n272 vss vdd PAOI22
XG368 n273 acc3 n241 vss vdd PNAND2
XG369 n274 n270 alu_c3 vss vdd PNAND2
XG370 alu_c4 n273 n274 vss vdd PNAND2
XG371 n275 acc0 acc1 vss vdd PNAND2
XG372 n276 n275 vss vdd PINV
XG373 n277 acc0 acc2 vss vdd PNAND2
XG374 n278 n277 vss vdd PINV
XG375 n279 acc0 acc3 vss vdd PNAND2
XG376 n280 n279 vss vdd PINV
XG377 n281 acc1 acc2 vss vdd PNAND2
XG378 n282 n281 vss vdd PINV
XG379 n283 acc1 acc3 vss vdd PNAND2
XG380 n284 n283 vss vdd PINV
XG381 n285 acc2 acc3 vss vdd PNAND2
XG382 n286 n285 vss vdd PINV
XG383 n287 n276 n278 n280 n282 n284 n286 vss vdd PNOR6
XG384 n288 n287 vss vdd PINV
XG385 n289 acc0 acc2 n288 vss vdd PNOR3
XG386 n290 n289 vss vdd PINV
XG387 n291 acc1 acc2 n288 vss vdd PNOR3
XG388 n292 n291 vss vdd PINV
XG389 n293 acc3 n288 vss vdd PNOR2
XG390 n294 n293 vss vdd PINV
XG391 n295 n105 n221 n87 n99 vss vdd PNOR4
XG392 n296 n295 vss vdd PINV S=2
XG393 n297 i_ld i_xch vss vdd PNOR2
XG394 n298 n297 vss vdd PINV S=2
XG395 n299 i_bbl i_ldm vss vdd PNOR2
XG396 n300 n299 vss vdd PINV S=2
XG397 n301 n296 alu_s0 n298 rd0 n300 opa0 n81 bi0 vss vdd PAOI2222
XG398 n302 n107 n290 n91 n247 n93 cy n95 acc1 vss vdd PAOI2222
XG399 n303 n101 n242 n97 cy vss vdd PAOI22
XG400 acc_d0 n301 n302 n303 vss vdd PNAND3
XG401 n304 n296 alu_s1 n298 rd1 n300 opa1 vss vdd PAOI222
XG402 n305 n81 bi1 n91 n254 n93 acc0 vss vdd PAOI222
XG403 n306 n101 cy n107 n292 n95 acc2 vss vdd PAOI222
XG404 acc_d1 n304 n305 n306 vss vdd PNAND3
XG405 n307 n296 alu_s2 n298 rd2 n300 opa2 vss vdd PAOI222
XG406 n308 n81 bi2 n91 n261 n93 acc1 vss vdd PAOI222
XG407 n309 n107 n294 n95 acc3 vss vdd PAOI22
XG408 acc_d2 n307 n308 n309 vss vdd PNAND3
XG409 n310 n296 alu_s3 n298 rd3 n300 opa3 vss vdd PAOI222
XG410 n311 n81 bi3 n91 n268 n93 acc2 vss vdd PAOI222
XG411 n312 n107 n288 n95 cy n101 vss vdd PAOI221
XG412 acc_d3 n310 n311 n312 vss vdd PNAND3
XG413 n313 n43 n47 n51 n53 n55 n57 n58 n59 vss vdd PNOR8
XG414 n314 n61 n62 vss vdd PNOR2
XG415 n315 n313 n314 vss vdd PNAND2
XG416 n316 i_acc n315 vss vdd PNAND2
XG417 n317 n316 vss vdd PINV
XG418 n318 i_add i_bbl i_ld i_ldm i_sub i_xch n317 vss vdd PNOR7
XG419 n319 n318 vss vdd PINV
XG420 n320 s_x1 n319 vss vdd PNAND2
XG421 n321 n320 vss vdd PINV
XG422 n322 s_x2 i_ior vss vdd PNAND2
XG423 n323 n322 vss vdd PINV
XG424 n324 n321 n323 vss vdd PNOR2
XG425 n325 n324 vss vdd PINV
XG426 n326 ndc_b0 n325 vss vdd PNAND2
XG427 acc_we n326 vss vdd PINV S=3
XG428 n327 acc_we vss vdd PINV S=2
Xr_acc0 acc0 acc_d0 acc_we n327 rb_b10 phi1 phi2 vss vdd DLER S=5
Xr_acc1 acc1 acc_d1 acc_we n327 rb_b11 phi1 phi2 vss vdd DLER S=5
Xr_acc2 acc2 acc_d2 acc_we n327 rb_b11 phi1 phi2 vss vdd DLER S=5
Xr_acc3 acc3 acc_d3 acc_we n327 rb_b11 phi1 phi2 vss vdd DLER S=5
XG429 n328 n221 n87 n99 vss vdd PNOR3
XG430 n329 n328 vss vdd PINV
XG431 n330 n105 alu_c4 cy n329 vss vdd PCG15
XG432 n331 n89 n242 n93 acc3 n103 vss vdd PAOI221
XG433 n332 n95 acc0 vss vdd PNAND2
XG434 cy_d n330 n331 n332 vss vdd PNAND3
XG435 n333 n43 n45 n47 n49 n53 n55 n57 n58 vss vdd PNOR8
XG436 n334 n59 n60 n61 vss vdd PNOR3
XG437 n335 n333 n334 vss vdd PNAND2
XG438 n336 i_acc n335 vss vdd PNAND2
XG439 n337 n336 vss vdd PINV
XG440 n338 i_add i_sub n337 vss vdd PNOR3
XG441 n339 n338 vss vdd PINV
XG442 n340 s_x1 n339 vss vdd PNAND2
XG443 n341 n340 vss vdd PINV
XG444 n342 s_x2 n218 vss vdd PNAND2
XG445 n343 n342 vss vdd PINV
XG446 n344 n341 n343 vss vdd PNOR2
XG447 n345 n344 vss vdd PINV
XG448 n346 ndc_b0 n345 vss vdd PNAND2
XG449 cy_we n346 vss vdd PINV
XG450 n347 cy_we vss vdd PINV
Xr_cy cy cy_d cy_we n347 rb_b11 phi1 phi2 vss vdd DLER S=4
* ---- DCL bank register
XG451 n348 ndc_b0 s_x1 n109 vss vdd PNAND3
XG452 dcl_we n348 vss vdd PINV S=2
XG453 n349 dcl_we vss vdd PINV S=2
Xr_dcl0 dcl0 acc0 dcl_we n349 rb_b11 phi1 phi2 vss vdd DLER
Xr_dcl1 dcl1 acc1 dcl_we n349 rb_b11 phi1 phi2 vss vdd DLER
Xr_dcl2 dcl2 acc2 dcl_we n349 rb_b11 phi1 phi2 vss vdd DLER
* ---- jump condition (sampled at A3 of the second word)
XG454 acc_zero acc0 acc1 acc2 acc3 vss vdd PNOR4
XG455 n350 opa0 ntest opa1 cy opa2 acc_zero vss vdd PAOI222
XG456 n351 n350 vss vdd PINV
XG457 jcn_cond n350 n40 n351 opa3 vss vdd PAOI22
XG458 n352 dc s_a3 vss vdd PNAND2
XG459 n353 n352 vss vdd PINV
Xr_cond cond jcn_cond n353 n352 rb_b12 phi1 phi2 vss vdd DLER
XG460 n354 rd0 rd1 rd2 rd3 vss vdd PNOR4
XG461 rd_nz n354 vss vdd PINV
XG462 n355 i_jcn cond vss vdd PNAND2
XG463 n356 n355 vss vdd PINV
XG464 n357 i_isz rd_nz vss vdd PNAND2
XG465 n358 n357 vss vdd PINV
XG466 n359 i_jms i_jun n356 n358 vss vdd PNOR4
XG467 n360 n359 vss vdd PINV
XG468 n361 dc n360 vss vdd PNAND2
XG469 take2 n361 vss vdd PINV
* ---- address stack 4 x 12 (PC + 3 levels), nibble-serial incrementer
XG470 n362 sp0 vss vdd PINV S=2
XG471 n363 sp1 vss vdd PINV S=2
XG472 n364 n363 n362 sp1 sp0 vss vdd PAOI22
XG473 n365 n363 sp0 sp1 n362 vss vdd PAOI22
XG474 n366 dc s_a3 i_jms vss vdd PNAND3
XG475 n367 n366 vss vdd PINV
XG476 n368 ndc_b0 s_x1 i_bbl vss vdd PNAND3
XG477 n369 n368 vss vdd PINV
XG478 n370 n367 n369 vss vdd PNOR2
XG479 sp_we n370 vss vdd PINV S=2
XG480 n371 sp_we vss vdd PINV
Xr_sp0 sp0 n362 sp_we n371 rb_b12 phi1 phi2 vss vdd DLER S=3
XG481 n372 dc n364 n128 n365 vss vdd PAOI22
XG482 n373 n372 vss vdd PINV
Xr_sp1 sp1 n373 sp_we n371 rb_b12 phi1 phi2 vss vdd DLER S=3
XG483 n374 n363 n362 vss vdd PNAND2
XG484 spsel0 n374 vss vdd PINV S=3
XG485 n375 n363 sp0 vss vdd PNAND2
XG486 spsel1 n375 vss vdd PINV S=3
XG487 n376 sp1 n362 vss vdd PNAND2
XG488 spsel2 n376 vss vdd PINV S=3
XG489 n377 sp1 sp0 vss vdd PNAND2
XG490 spsel3 n377 vss vdd PINV S=3
XG491 n378 s_a1 s_a2 s_a3 vss vdd PNOR3
XG492 s_aany n378 vss vdd PINV S=2
XG493 n379 s_x2 s_x3 vss vdd PNOR2
XG494 n380 n379 vss vdd PINV S=3
XG495 n381 s_a1 s_a2 vss vdd PNOR2
XG496 n382 n381 vss vdd PINV
XG497 n383 n382 inc_c4 vss vdd PNAND2
XG498 n384 n383 vss vdd PINV
Xr_acarry acarry n384 rb_b12 phi1 phi2 vss vdd DLR
XG499 n385 acarry s_a1 vss vdd PNOR2
XG500 inc_c0 n385 vss vdd PINV
XG501 n386 srd0 vss vdd PINV
XG502 n387 inc_c0 vss vdd PINV
XG503 inc0 n386 n387 srd0 inc_c0 vss vdd PAOI22
XG504 n388 srd0 inc_c0 vss vdd PNAND2
XG505 inc_c1 n388 vss vdd PINV
XG506 n389 srd1 vss vdd PINV
XG507 n390 inc_c1 vss vdd PINV
XG508 inc1 n389 n390 srd1 inc_c1 vss vdd PAOI22
XG509 n391 srd1 inc_c1 vss vdd PNAND2
XG510 inc_c2 n391 vss vdd PINV
XG511 n392 srd2 vss vdd PINV
XG512 n393 inc_c2 vss vdd PINV
XG513 inc2 n392 n393 srd2 inc_c2 vss vdd PAOI22
XG514 n394 srd2 inc_c2 vss vdd PNAND2
XG515 inc_c3 n394 vss vdd PINV
XG516 n395 srd3 vss vdd PINV
XG517 n396 inc_c3 vss vdd PINV
XG518 inc3 n395 n396 srd3 inc_c3 vss vdd PAOI22
XG519 n397 srd3 inc_c3 vss vdd PNAND2
XG520 inc_c4 n397 vss vdd PINV
XG521 n398 n380 ndc_b1 i_jin s_x1 dc i_jj n135 take2 s_aany n111 vss vdd PAOI3322
XG522 stk_we n398 vss vdd PINV S=6
XG523 n399 s_a1 s_m2 s_x3 vss vdd PNOR3
XG524 nw0 n399 vss vdd PINV S=2
XG525 n400 s_a2 s_m1 s_x2 vss vdd PNOR3
XG526 nw1 n400 vss vdd PINV S=2
XG527 n401 s_a3 s_x1 vss vdd PNOR2
XG528 nw2 n401 vss vdd PINV S=2
XG529 n402 n135 bi0 n380 rd0 s_aany inc0 s_x1 opa0 vss vdd PAOI2222
XG530 stk_wd0 n402 vss vdd PINV S=6
XG531 n403 n135 bi1 n380 rd1 s_aany inc1 s_x1 opa1 vss vdd PAOI2222
XG532 stk_wd1 n403 vss vdd PINV S=6
XG533 n404 n135 bi2 n380 rd2 s_aany inc2 s_x1 opa2 vss vdd PAOI2222
XG534 stk_wd2 n404 vss vdd PINV S=6
XG535 n405 n135 bi3 n380 rd3 s_aany inc3 s_x1 opa3 vss vdd PAOI2222
XG536 stk_wd3 n405 vss vdd PINV S=6
XG537 n406 stk_we spsel0 nw0 vss vdd PNAND3
XG538 swen0_0 n406 vss vdd PINV S=3
XG539 n407 swen0_0 vss vdd PINV S=2
Xs0_0_0 s0_0_0 stk_wd0 swen0_0 n407 rb_b12 phi1 phi2 vss vdd DLER
Xs0_0_1 s0_0_1 stk_wd1 swen0_0 n407 rb_b12 phi1 phi2 vss vdd DLER
Xs0_0_2 s0_0_2 stk_wd2 swen0_0 n407 rb_b12 phi1 phi2 vss vdd DLER
Xs0_0_3 s0_0_3 stk_wd3 swen0_0 n407 rb_b13 phi1 phi2 vss vdd DLER
XG540 n408 stk_we spsel0 nw1 vss vdd PNAND3
XG541 swen0_1 n408 vss vdd PINV S=3
XG542 n409 swen0_1 vss vdd PINV S=2
Xs0_1_0 s0_1_0 stk_wd0 swen0_1 n409 rb_b13 phi1 phi2 vss vdd DLER
Xs0_1_1 s0_1_1 stk_wd1 swen0_1 n409 rb_b13 phi1 phi2 vss vdd DLER
Xs0_1_2 s0_1_2 stk_wd2 swen0_1 n409 rb_b13 phi1 phi2 vss vdd DLER
Xs0_1_3 s0_1_3 stk_wd3 swen0_1 n409 rb_b13 phi1 phi2 vss vdd DLER
XG543 n410 stk_we spsel0 nw2 vss vdd PNAND3
XG544 swen0_2 n410 vss vdd PINV S=3
XG545 n411 swen0_2 vss vdd PINV S=2
Xs0_2_0 s0_2_0 stk_wd0 swen0_2 n411 rb_b13 phi1 phi2 vss vdd DLER
Xs0_2_1 s0_2_1 stk_wd1 swen0_2 n411 rb_b13 phi1 phi2 vss vdd DLER
Xs0_2_2 s0_2_2 stk_wd2 swen0_2 n411 rb_b14 phi1 phi2 vss vdd DLER
Xs0_2_3 s0_2_3 stk_wd3 swen0_2 n411 rb_b14 phi1 phi2 vss vdd DLER
XG546 n412 stk_we spsel1 nw0 vss vdd PNAND3
XG547 swen1_0 n412 vss vdd PINV S=3
XG548 n413 swen1_0 vss vdd PINV S=2
Xs1_0_0 s1_0_0 stk_wd0 swen1_0 n413 rb_b14 phi1 phi2 vss vdd DLER
Xs1_0_1 s1_0_1 stk_wd1 swen1_0 n413 rb_b14 phi1 phi2 vss vdd DLER
Xs1_0_2 s1_0_2 stk_wd2 swen1_0 n413 rb_b14 phi1 phi2 vss vdd DLER
Xs1_0_3 s1_0_3 stk_wd3 swen1_0 n413 rb_b14 phi1 phi2 vss vdd DLER
XG549 n414 stk_we spsel1 nw1 vss vdd PNAND3
XG550 swen1_1 n414 vss vdd PINV S=3
XG551 n415 swen1_1 vss vdd PINV S=2
Xs1_1_0 s1_1_0 stk_wd0 swen1_1 n415 rb_b14 phi1 phi2 vss vdd DLER
Xs1_1_1 s1_1_1 stk_wd1 swen1_1 n415 rb_b15 phi1 phi2 vss vdd DLER
Xs1_1_2 s1_1_2 stk_wd2 swen1_1 n415 rb_b15 phi1 phi2 vss vdd DLER
Xs1_1_3 s1_1_3 stk_wd3 swen1_1 n415 rb_b15 phi1 phi2 vss vdd DLER
XG552 n416 stk_we spsel1 nw2 vss vdd PNAND3
XG553 swen1_2 n416 vss vdd PINV S=3
XG554 n417 swen1_2 vss vdd PINV S=2
Xs1_2_0 s1_2_0 stk_wd0 swen1_2 n417 rb_b15 phi1 phi2 vss vdd DLER
Xs1_2_1 s1_2_1 stk_wd1 swen1_2 n417 rb_b15 phi1 phi2 vss vdd DLER
Xs1_2_2 s1_2_2 stk_wd2 swen1_2 n417 rb_b15 phi1 phi2 vss vdd DLER
Xs1_2_3 s1_2_3 stk_wd3 swen1_2 n417 rb_b15 phi1 phi2 vss vdd DLER
XG555 n418 stk_we spsel2 nw0 vss vdd PNAND3
XG556 swen2_0 n418 vss vdd PINV S=3
XG557 n419 swen2_0 vss vdd PINV S=2
Xs2_0_0 s2_0_0 stk_wd0 swen2_0 n419 rb_b16 phi1 phi2 vss vdd DLER
Xs2_0_1 s2_0_1 stk_wd1 swen2_0 n419 rb_b16 phi1 phi2 vss vdd DLER
Xs2_0_2 s2_0_2 stk_wd2 swen2_0 n419 rb_b16 phi1 phi2 vss vdd DLER
Xs2_0_3 s2_0_3 stk_wd3 swen2_0 n419 rb_b16 phi1 phi2 vss vdd DLER
XG558 n420 stk_we spsel2 nw1 vss vdd PNAND3
XG559 swen2_1 n420 vss vdd PINV S=3
XG560 n421 swen2_1 vss vdd PINV S=2
Xs2_1_0 s2_1_0 stk_wd0 swen2_1 n421 rb_b16 phi1 phi2 vss vdd DLER
Xs2_1_1 s2_1_1 stk_wd1 swen2_1 n421 rb_b16 phi1 phi2 vss vdd DLER
Xs2_1_2 s2_1_2 stk_wd2 swen2_1 n421 rb_b16 phi1 phi2 vss vdd DLER
Xs2_1_3 s2_1_3 stk_wd3 swen2_1 n421 rb_b17 phi1 phi2 vss vdd DLER
XG561 n422 stk_we spsel2 nw2 vss vdd PNAND3
XG562 swen2_2 n422 vss vdd PINV S=3
XG563 n423 swen2_2 vss vdd PINV S=2
Xs2_2_0 s2_2_0 stk_wd0 swen2_2 n423 rb_b17 phi1 phi2 vss vdd DLER
Xs2_2_1 s2_2_1 stk_wd1 swen2_2 n423 rb_b17 phi1 phi2 vss vdd DLER
Xs2_2_2 s2_2_2 stk_wd2 swen2_2 n423 rb_b17 phi1 phi2 vss vdd DLER
Xs2_2_3 s2_2_3 stk_wd3 swen2_2 n423 rb_b17 phi1 phi2 vss vdd DLER
XG564 n424 stk_we spsel3 nw0 vss vdd PNAND3
XG565 swen3_0 n424 vss vdd PINV S=3
XG566 n425 swen3_0 vss vdd PINV S=2
Xs3_0_0 s3_0_0 stk_wd0 swen3_0 n425 rb_b17 phi1 phi2 vss vdd DLER
Xs3_0_1 s3_0_1 stk_wd1 swen3_0 n425 rb_b17 phi1 phi2 vss vdd DLER
Xs3_0_2 s3_0_2 stk_wd2 swen3_0 n425 rb_b18 phi1 phi2 vss vdd DLER
Xs3_0_3 s3_0_3 stk_wd3 swen3_0 n425 rb_b18 phi1 phi2 vss vdd DLER
XG567 n426 stk_we spsel3 nw1 vss vdd PNAND3
XG568 swen3_1 n426 vss vdd PINV S=3
XG569 n427 swen3_1 vss vdd PINV S=2
Xs3_1_0 s3_1_0 stk_wd0 swen3_1 n427 rb_b18 phi1 phi2 vss vdd DLER
Xs3_1_1 s3_1_1 stk_wd1 swen3_1 n427 rb_b18 phi1 phi2 vss vdd DLER
Xs3_1_2 s3_1_2 stk_wd2 swen3_1 n427 rb_b18 phi1 phi2 vss vdd DLER
Xs3_1_3 s3_1_3 stk_wd3 swen3_1 n427 rb_b18 phi1 phi2 vss vdd DLER
XG570 n428 stk_we spsel3 nw2 vss vdd PNAND3
XG571 swen3_2 n428 vss vdd PINV S=3
XG572 n429 swen3_2 vss vdd PINV S=2
Xs3_2_0 s3_2_0 stk_wd0 swen3_2 n429 rb_b18 phi1 phi2 vss vdd DLER
Xs3_2_1 s3_2_1 stk_wd1 swen3_2 n429 rb_b19 phi1 phi2 vss vdd DLER
Xs3_2_2 s3_2_2 stk_wd2 swen3_2 n429 rb_b19 phi1 phi2 vss vdd DLER
Xs3_2_3 s3_2_3 stk_wd3 swen3_2 n429 rb_b19 phi1 phi2 vss vdd DLER
XG573 n430 spsel0 s_a1 vss vdd PNAND2
XG574 srsel0_0 n430 vss vdd PINV S=2
XG575 n431 spsel0 s_a2 vss vdd PNAND2
XG576 srsel0_1 n431 vss vdd PINV S=2
XG577 n432 spsel0 s_a3 vss vdd PNAND2
XG578 srsel0_2 n432 vss vdd PINV S=2
XG579 n433 spsel1 s_a1 vss vdd PNAND2
XG580 srsel1_0 n433 vss vdd PINV S=2
XG581 n434 spsel1 s_a2 vss vdd PNAND2
XG582 srsel1_1 n434 vss vdd PINV S=2
XG583 n435 spsel1 s_a3 vss vdd PNAND2
XG584 srsel1_2 n435 vss vdd PINV S=2
XG585 n436 spsel2 s_a1 vss vdd PNAND2
XG586 srsel2_0 n436 vss vdd PINV S=2
XG587 n437 spsel2 s_a2 vss vdd PNAND2
XG588 srsel2_1 n437 vss vdd PINV S=2
XG589 n438 spsel2 s_a3 vss vdd PNAND2
XG590 srsel2_2 n438 vss vdd PINV S=2
XG591 n439 spsel3 s_a1 vss vdd PNAND2
XG592 srsel3_0 n439 vss vdd PINV S=2
XG593 n440 spsel3 s_a2 vss vdd PNAND2
XG594 srsel3_1 n440 vss vdd PINV S=2
XG595 n441 spsel3 s_a3 vss vdd PNAND2
XG596 srsel3_2 n441 vss vdd PINV S=2
XG597 n442 srsel0_0 s0_0_0 srsel0_1 s0_1_0 srsel0_2 s0_2_0 srsel1_0 s1_0_0 vss vdd PAOI2222
XG598 n443 srsel1_1 s1_1_0 srsel1_2 s1_2_0 srsel2_0 s2_0_0 srsel2_1 s2_1_0 vss vdd PAOI2222
XG599 n444 srsel2_2 s2_2_0 srsel3_0 s3_0_0 srsel3_1 s3_1_0 srsel3_2 s3_2_0 vss vdd PAOI2222
XG600 srd0 n442 n443 n444 vss vdd PNAND3 S=2
XG601 n445 srsel0_0 s0_0_1 srsel0_1 s0_1_1 srsel0_2 s0_2_1 srsel1_0 s1_0_1 vss vdd PAOI2222
XG602 n446 srsel1_1 s1_1_1 srsel1_2 s1_2_1 srsel2_0 s2_0_1 srsel2_1 s2_1_1 vss vdd PAOI2222
XG603 n447 srsel2_2 s2_2_1 srsel3_0 s3_0_1 srsel3_1 s3_1_1 srsel3_2 s3_2_1 vss vdd PAOI2222
XG604 srd1 n445 n446 n447 vss vdd PNAND3 S=2
XG605 n448 srsel0_0 s0_0_2 srsel0_1 s0_1_2 srsel0_2 s0_2_2 srsel1_0 s1_0_2 vss vdd PAOI2222
XG606 n449 srsel1_1 s1_1_2 srsel1_2 s1_2_2 srsel2_0 s2_0_2 srsel2_1 s2_1_2 vss vdd PAOI2222
XG607 n450 srsel2_2 s2_2_2 srsel3_0 s3_0_2 srsel3_1 s3_1_2 srsel3_2 s3_2_2 vss vdd PAOI2222
XG608 srd2 n448 n449 n450 vss vdd PNAND3 S=2
XG609 n451 srsel0_0 s0_0_3 srsel0_1 s0_1_3 srsel0_2 s0_2_3 srsel1_0 s1_0_3 vss vdd PAOI2222
XG610 n452 srsel1_1 s1_1_3 srsel1_2 s1_2_3 srsel2_0 s2_0_3 srsel2_1 s2_1_3 vss vdd PAOI2222
XG611 n453 srsel2_2 s2_2_3 srsel3_0 s3_0_3 srsel3_1 s3_1_3 srsel3_2 s3_2_3 vss vdd PAOI2222
XG612 srd3 n451 n452 n453 vss vdd PNAND3 S=2
* ---- data bus output
XG613 n454 n382 n111 vss vdd PNAND2
XG614 n455 n454 vss vdd PINV
XG615 n456 n455 s_a3 vss vdd PNOR2
XG616 n457 n456 vss vdd PINV S=2
XG617 n458 fin2 n382 vss vdd PNAND2
XG618 n459 n458 vss vdd PINV
XG619 n460 ndc_b1 i_src n380 vss vdd PNAND3
XG620 n461 n460 vss vdd PINV
XG621 n462 n459 n461 vss vdd PNOR2
XG622 n463 n462 vss vdd PINV S=2
XG623 n464 ndc_b1 s_x2 i_iow vss vdd PNAND3
XG624 n465 n464 vss vdd PINV S=2
XG625 n466 n457 srd0 n463 rd0 n465 acc0 vss vdd PAOI222
XG626 do0 n466 vss vdd PINV
XG627 n467 n457 srd1 n463 rd1 n465 acc1 vss vdd PAOI222
XG628 do1 n467 vss vdd PINV
XG629 n468 n457 srd2 n463 rd2 n465 acc2 vss vdd PAOI222
XG630 do2 n468 vss vdd PINV
XG631 n469 n457 srd3 n463 rd3 n465 acc3 vss vdd PAOI222
XG632 do3 n469 vss vdd PINV
XG633 n470 i_iow i_src vss vdd PNOR2
XG634 n471 n470 vss vdd PINV
XG635 n472 ndc_b1 s_x1 n471 vss vdd PNAND3
XG636 n473 n472 vss vdd PINV
XG637 n474 ndc_b1 s_x2 i_src vss vdd PNAND3
XG638 n475 n474 vss vdd PINV
XG639 n476 n1 n473 n475 s_a1 s_a2 s_x3 vss vdd PNOR6
XG640 doe_next n476 vss vdd PINV
Xr_doe doe doe_next phi1 phi2 vss vdd DL S=2
XG641 n477 doe vss vdd PINV
XG642 n478 do0 n477 vss vdd PNOR2
XG643 n479 doe do0 vss vdd PNAND2
Xbs_d0 n480 n479 vss vdd BSINV
Xpad_d0 d0 n478 n480 vss vdd PADDRV
XG644 n481 do1 n477 vss vdd PNOR2
XG645 n482 doe do1 vss vdd PNAND2
Xbs_d1 n483 n482 vss vdd BSINV
Xpad_d1 d1 n481 n483 vss vdd PADDRV
XG646 n484 do2 n477 vss vdd PNOR2
XG647 n485 doe do2 vss vdd PNAND2
Xbs_d2 n486 n485 vss vdd BSINV
Xpad_d2 d2 n484 n486 vss vdd PADDRV
XG648 n487 do3 n477 vss vdd PNOR2
XG649 n488 doe do3 vss vdd PNAND2
Xbs_d3 n489 n488 vss vdd BSINV
Xpad_d3 d3 n487 n489 vss vdd PADDRV
* ---- SYNC, CM-ROM, CM-RAM outputs (registered: clocked out at the sub-cycle start)
XG650 n490 bi0 vss vdd PINV
XG651 n491 bi3 bi2 bi1 vss vdd PNAND3
XG652 n492 n490 vss vdd PINV
XG653 bus_is_io n491 n492 vss vdd PNOR2
XG654 n493 ndc_b1 s_m1 bus_is_io vss vdd PNAND3
XG655 n494 n493 vss vdd PINV
XG656 n495 ndc_b1 s_x1 i_src vss vdd PNAND3
XG657 n496 n495 vss vdd PINV
XG658 n497 n494 n496 s_a2 vss vdd PNOR3
XG659 cm_next n497 vss vdd PINV S=2
Xr_q_sync q_sync s_x2 rb_b19 phi1 phi2 vss vdd DLR
Xr_q_cmrom q_cmrom cm_next rb_b19 phi1 phi2 vss vdd DLR
XG660 n498 dcl0 dcl1 dcl2 vss vdd PNOR3
XG661 n499 cm_next n498 vss vdd PNAND2
XG662 n500 n499 vss vdd PINV
Xr_q_cmram0 q_cmram0 n500 rb_b19 phi1 phi2 vss vdd DLR
XG663 n501 cm_next dcl0 vss vdd PNAND2
XG664 n502 n501 vss vdd PINV
Xr_q_cmram1 q_cmram1 n502 rb_b19 phi1 phi2 vss vdd DLR
XG665 n503 cm_next dcl1 vss vdd PNAND2
XG666 n504 n503 vss vdd PINV
Xr_q_cmram2 q_cmram2 n504 rb_b19 phi1 phi2 vss vdd DLR
XG667 n505 cm_next dcl2 vss vdd PNAND2
XG668 n506 n505 vss vdd PINV
Xr_q_cmram3 q_cmram3 n506 rb_b19 phi1 phi2 vss vdd DLR
XG669 n507 q_sync vss vdd PINV S=2
Xbs_sync n508 n507 vss vdd BSINV
Xpad_sync sync n507 n508 vss vdd PADDRV
XG670 n509 q_cmrom vss vdd PINV S=2
Xbs_cmrom n510 n509 vss vdd BSINV
Xpad_cmrom cmrom n509 n510 vss vdd PADDRV
XG671 n511 q_cmram0 vss vdd PINV S=2
Xbs_cmram0 n512 n511 vss vdd BSINV
Xpad_cmram0 cmram0 n511 n512 vss vdd PADDRV
XG672 n513 q_cmram1 vss vdd PINV S=2
Xbs_cmram1 n514 n513 vss vdd BSINV
Xpad_cmram1 cmram1 n513 n514 vss vdd PADDRV
XG673 n515 q_cmram2 vss vdd PINV S=2
Xbs_cmram2 n516 n515 vss vdd BSINV
Xpad_cmram2 cmram2 n515 n516 vss vdd PADDRV
XG674 n517 q_cmram3 vss vdd PINV S=2
Xbs_cmram3 n518 n517 vss vdd BSINV
Xpad_cmram3 cmram3 n517 n518 vss vdd PADDRV
* ---- fan-out buffer trees (inserted automatically)
XG675 n519 rb vss vdd PINV S=6
XG676 rb_b0 n519 vss vdd PINV S=4
XG677 rb_b1 n519 vss vdd PINV S=4
XG678 rb_b2 n519 vss vdd PINV S=4
XG679 rb_b3 n519 vss vdd PINV S=4
XG680 rb_b4 n519 vss vdd PINV S=4
XG681 rb_b5 n519 vss vdd PINV S=4
XG682 rb_b6 n519 vss vdd PINV S=4
XG683 rb_b7 n519 vss vdd PINV S=4
XG684 rb_b8 n519 vss vdd PINV S=4
XG685 rb_b9 n519 vss vdd PINV S=4
XG686 rb_b10 n519 vss vdd PINV S=4
XG687 rb_b11 n519 vss vdd PINV S=4
XG688 rb_b12 n519 vss vdd PINV S=4
XG689 rb_b13 n519 vss vdd PINV S=4
XG690 rb_b14 n519 vss vdd PINV S=4
XG691 rb_b15 n519 vss vdd PINV S=4
XG692 rb_b16 n519 vss vdd PINV S=4
XG693 rb_b17 n519 vss vdd PINV S=4
XG694 rb_b18 n519 vss vdd PINV S=4
XG695 rb_b19 n519 vss vdd PINV S=4
XG696 n520 ndc vss vdd PINV S=2
XG697 ndc_b0 n520 vss vdd PINV S=4
XG698 ndc_b1 n520 vss vdd PINV S=4
XG699 n521 rf_wd0 vss vdd PINV S=2
XG700 rf_wd0_b0 n521 vss vdd PINV S=4
XG701 rf_wd0_b1 n521 vss vdd PINV S=4
XG702 rf_wd0_b2 n521 vss vdd PINV
XG703 n522 rf_wd1 vss vdd PINV S=2
XG704 rf_wd1_b0 n522 vss vdd PINV S=4
XG705 rf_wd1_b1 n522 vss vdd PINV S=4
XG706 rf_wd1_b2 n522 vss vdd PINV
XG707 n523 rf_wd2 vss vdd PINV S=2
XG708 rf_wd2_b0 n523 vss vdd PINV S=4
XG709 rf_wd2_b1 n523 vss vdd PINV S=4
XG710 rf_wd2_b2 n523 vss vdd PINV
XG711 n524 rf_wd3 vss vdd PINV S=2
XG712 rf_wd3_b0 n524 vss vdd PINV S=4
XG713 rf_wd3_b1 n524 vss vdd PINV S=4
XG714 rf_wd3_b2 n524 vss vdd PINV
.ends I4004P

*=============================================================================
*  TESTBENCH KNOBS
*=============================================================================
*  Original MCS-4 conditions: VSS = 0 V (ground), VDD = -15 V, 740 kHz
*  two-phase clock (400 ns pulses, 400 ns PHI1->PHI2, 150 ns PHI2->PHI1).
*  Negative logic: logic 1 = negative voltage, logic 0 = VSS.
*-----------------------------------------------------------------------------
.param VDDV=-15
.param TCLK=1.35u TPW=0.4u TD1=0.4u TRF=20n
.param CBUS=10p CLOAD=10p
.param NPER=168
.param TSTOP={NPER*TCLK}

* the CPU, pins in DIP order 1..16 (pin 5 VSS = ground, pin 12 VDD)
XCPU d0 d1 d2 d3 0 phi1 phi2 sync reset test cmrom vdd cmram3 cmram2 cmram1 cmram0
+ I4004P

VVDD vdd 0 {VDDV}
VPHI1 phi1 0 PULSE(0 {VDDV} 0 {TRF} {TRF} {TPW-TRF} {TCLK})
VPHI2 phi2 0 PULSE(0 {VDDV} {TPW+TD1} {TRF} {TRF} {TPW-TRF} {TCLK})
* RESET (logic 1 = VDD) held for 8 clock periods, released during PHI1
VRESET reset 0 PWL(0 {VDDV} {8.1*TCLK} {VDDV} {8.1*TCLK+TRF} 0)
* TEST pin at logic 0 (VSS)
VTEST test 0 0

* bus and output loading
CB0 d0 0 {CBUS}
CB1 d1 0 {CBUS}
CB2 d2 0 {CBUS}
CB3 d3 0 {CBUS}
RK0 d0 0 1Meg
RK1 d1 0 1Meg
RK2 d2 0 1Meg
RK3 d3 0 1Meg
CL1 sync 0 {CLOAD}
CL2 cmrom 0 {CLOAD}
CL3 cmram0 0 {CLOAD}
CL4 cmram1 0 {CLOAD}
CL5 cmram2 0 {CLOAD}
CL6 cmram3 0 {CLOAD}

* bus nibble as one staircase trace (logic 1 = below -4 V)
BBUS busval 0 V=u(-4-V(d0))+2*u(-4-V(d1))+4*u(-4-V(d2))+8*u(-4-V(d3))

*-----------------------------------------------------------------------------
*  MCS-4 memory system as a Verilog-A device (mcs4mem.va -> mcs4mem.osdi):
*  4001 ROM holding the program below + 4002 RAM bank 0 + I/O ports.
*  rport = ROM output port 0 value (0..15 V), mport = RAM chip 0 output port.
*  Compile first:   openvaf mcs4mem.va      (OpenVAF / OpenVAF-reloaded)
*-----------------------------------------------------------------------------
NMEM d0 d1 d2 d3 phi1 phi2 sync reset cmrom cmram0 rport mport mcs4mem_m
.model mcs4mem_m mcs4mem
*-----------------------------------------------------------------------------
*  Program in the external ROM
*-----------------------------------------------------------------------------
*   000: D0      LDM 0
*   001: FD      DCL
*   002: 2E 00   FIM P7, 0x00
*   004: 2F      SRC P7
*   005: D0      LDM 0
*   006: E1      WMP
*   007: E2      WRR
*   008: D1      LDM 1
*   009: BD      XCH R13
*   00A: 54 03   JMS SHOW
*   00C: F0      CLB
*   00D: 1A 11   JCN C0, K001
*   00F: 43 FA   JUN FAIL
*   011: 14 15   JCN AZ, K002
*   013: 43 FA   JUN FAIL
*   015: FA      STC
*   016: 12 1A   JCN C1, K003
*   018: 43 FA   JUN FAIL
*   01A: F3      CMC
*   01B: 1A 1F   JCN C0, K004
*   01D: 43 FA   JUN FAIL
*   01F: F3      CMC
*   020: 12 24   JCN C1, K005
*   022: 43 FA   JUN FAIL
*   024: F1      CLC
*   025: 1A 29   JCN C0, K006
*   027: 43 FA   JUN FAIL
*   029: FA      STC
*   02A: F7      TCC
*   02B: 1A 2F   JCN C0, K007
*   02D: 43 FA   JUN FAIL
*   02F: BB      XCH R11
*   030: D1      LDM 1
*   031: F1      CLC
*   032: 9B      SUB R11
*   033: 14 37   JCN AZ, K008
*   035: 43 FA   JUN FAIL
*   037: D5      LDM 5
*   038: F4      CMA
*   039: BB      XCH R11
*   03A: DA      LDM 10
*   03B: F1      CLC
*   03C: 9B      SUB R11
*   03D: 14 41   JCN AZ, K009
*   03F: 43 FA   JUN FAIL
*   041: DF      LDM 15
*   042: F1      CLC
*   043: F2      IAC
*   044: 12 48   JCN C1, K010
*   046: 43 FA   JUN FAIL
*   048: BB      XCH R11
*   049: D0      LDM 0
*   04A: F1      CLC
*   04B: 9B      SUB R11
*   04C: 14 50   JCN AZ, K011
*   04E: 43 FA   JUN FAIL
*   050: D0      LDM 0
*   051: F8      DAC
*   052: 1A 56   JCN C0, K012
*   054: 43 FA   JUN FAIL
*   056: BB      XCH R11
*   057: DF      LDM 15
*   058: F1      CLC
*   059: 9B      SUB R11
*   05A: 14 5E   JCN AZ, K013
*   05C: 43 FA   JUN FAIL
*   05E: D5      LDM 5
*   05F: F8      DAC
*   060: 12 64   JCN C1, K014
*   062: 43 FA   JUN FAIL
*   064: BB      XCH R11
*   065: D4      LDM 4
*   066: F1      CLC
*   067: 9B      SUB R11
*   068: 14 6C   JCN AZ, K015
*   06A: 43 FA   JUN FAIL
*   06C: D8      LDM 8
*   06D: F1      CLC
*   06E: F5      RAL
*   06F: 12 73   JCN C1, K016
*   071: 43 FA   JUN FAIL
*   073: BB      XCH R11
*   074: D0      LDM 0
*   075: F1      CLC
*   076: 9B      SUB R11
*   077: 14 7B   JCN AZ, K017
*   079: 43 FA   JUN FAIL
*   07B: D0      LDM 0
*   07C: FA      STC
*   07D: F5      RAL
*   07E: 1A 82   JCN C0, K018
*   080: 43 FA   JUN FAIL
*   082: BB      XCH R11
*   083: D1      LDM 1
*   084: F1      CLC
*   085: 9B      SUB R11
*   086: 14 8A   JCN AZ, K019
*   088: 43 FA   JUN FAIL
*   08A: D1      LDM 1
*   08B: F1      CLC
*   08C: F6      RAR
*   08D: 12 91   JCN C1, K020
*   08F: 43 FA   JUN FAIL
*   091: BB      XCH R11
*   092: D0      LDM 0
*   093: F1      CLC
*   094: 9B      SUB R11
*   095: 14 99   JCN AZ, K021
*   097: 43 FA   JUN FAIL
*   099: D0      LDM 0
*   09A: FA      STC
*   09B: F6      RAR
*   09C: 1A A0   JCN C0, K022
*   09E: 43 FA   JUN FAIL
*   0A0: BB      XCH R11
*   0A1: D8      LDM 8
*   0A2: F1      CLC
*   0A3: 9B      SUB R11
*   0A4: 14 A8   JCN AZ, K023
*   0A6: 43 FA   JUN FAIL
*   0A8: F1      CLC
*   0A9: F9      TCS
*   0AA: 1A AE   JCN C0, K024
*   0AC: 43 FA   JUN FAIL
*   0AE: BB      XCH R11
*   0AF: D9      LDM 9
*   0B0: F1      CLC
*   0B1: 9B      SUB R11
*   0B2: 14 B6   JCN AZ, K025
*   0B4: 43 FA   JUN FAIL
*   0B6: FA      STC
*   0B7: F9      TCS
*   0B8: 1A BC   JCN C0, K026
*   0BA: 43 FA   JUN FAIL
*   0BC: BB      XCH R11
*   0BD: DA      LDM 10
*   0BE: F1      CLC
*   0BF: 9B      SUB R11
*   0C0: 14 C4   JCN AZ, K027
*   0C2: 43 FA   JUN FAIL
*   0C4: D0      LDM 0
*   0C5: FC      KBP
*   0C6: BB      XCH R11
*   0C7: D0      LDM 0
*   0C8: F1      CLC
*   0C9: 9B      SUB R11
*   0CA: 14 CE   JCN AZ, K028
*   0CC: 43 FA   JUN FAIL
*   0CE: D4      LDM 4
*   0CF: FC      KBP
*   0D0: BB      XCH R11
*   0D1: D3      LDM 3
*   0D2: F1      CLC
*   0D3: 9B      SUB R11
*   0D4: 14 D8   JCN AZ, K029
*   0D6: 43 FA   JUN FAIL
*   0D8: D8      LDM 8
*   0D9: FC      KBP
*   0DA: BB      XCH R11
*   0DB: D4      LDM 4
*   0DC: F1      CLC
*   0DD: 9B      SUB R11
*   0DE: 14 E2   JCN AZ, K030
*   0E0: 43 FA   JUN FAIL
*   0E2: D3      LDM 3
*   0E3: FC      KBP
*   0E4: BB      XCH R11
*   0E5: DF      LDM 15
*   0E6: F1      CLC
*   0E7: 9B      SUB R11
*   0E8: 14 EC   JCN AZ, K031
*   0EA: 43 FA   JUN FAIL
*   0EC: DC      LDM 12
*   0ED: F1      CLC
*   0EE: FB      DAA
*   0EF: 12 F3   JCN C1, K032
*   0F1: 43 FA   JUN FAIL
*   0F3: BB      XCH R11
*   0F4: D2      LDM 2
*   0F5: F1      CLC
*   0F6: 9B      SUB R11
*   0F7: 14 FB   JCN AZ, K033
*   0F9: 43 FA   JUN FAIL
*   0FB: D5      LDM 5
*   0FC: F1      CLC
*   0FD: FB      DAA
*   0FE: 1A 02   JCN C0, K034
*   100: 43 FA   JUN FAIL
*   102: BB      XCH R11
*   103: D5      LDM 5
*   104: F1      CLC
*   105: 9B      SUB R11
*   106: 14 0A   JCN AZ, K035
*   108: 43 FA   JUN FAIL
*   10A: D3      LDM 3
*   10B: FA      STC
*   10C: FB      DAA
*   10D: 12 11   JCN C1, K036
*   10F: 43 FA   JUN FAIL
*   111: BB      XCH R11
*   112: D9      LDM 9
*   113: F1      CLC
*   114: 9B      SUB R11
*   115: 14 19   JCN AZ, K037
*   117: 43 FA   JUN FAIL
*   119: D2      LDM 2
*   11A: BD      XCH R13
*   11B: 54 03   JMS SHOW
*   11D: D7      LDM 7
*   11E: B1      XCH R1
*   11F: D9      LDM 9
*   120: F1      CLC
*   121: 81      ADD R1
*   122: 12 26   JCN C1, K038
*   124: 43 FA   JUN FAIL
*   126: BB      XCH R11
*   127: D0      LDM 0
*   128: F1      CLC
*   129: 9B      SUB R11
*   12A: 14 2E   JCN AZ, K039
*   12C: 43 FA   JUN FAIL
*   12E: D3      LDM 3
*   12F: FA      STC
*   130: 81      ADD R1
*   131: 1A 35   JCN C0, K040
*   133: 43 FA   JUN FAIL
*   135: BB      XCH R11
*   136: DB      LDM 11
*   137: F1      CLC
*   138: 9B      SUB R11
*   139: 14 3D   JCN AZ, K041
*   13B: 43 FA   JUN FAIL
*   13D: D9      LDM 9
*   13E: F1      CLC
*   13F: 91      SUB R1
*   140: 12 44   JCN C1, K042
*   142: 43 FA   JUN FAIL
*   144: BB      XCH R11
*   145: D2      LDM 2
*   146: F1      CLC
*   147: 9B      SUB R11
*   148: 14 4C   JCN AZ, K043
*   14A: 43 FA   JUN FAIL
*   14C: D5      LDM 5
*   14D: F1      CLC
*   14E: 91      SUB R1
*   14F: 1A 53   JCN C0, K044
*   151: 43 FA   JUN FAIL
*   153: BB      XCH R11
*   154: DE      LDM 14
*   155: F1      CLC
*   156: 9B      SUB R11
*   157: 14 5B   JCN AZ, K045
*   159: 43 FA   JUN FAIL
*   15B: D9      LDM 9
*   15C: FA      STC
*   15D: 91      SUB R1
*   15E: 12 62   JCN C1, K046
*   160: 43 FA   JUN FAIL
*   162: BB      XCH R11
*   163: D1      LDM 1
*   164: F1      CLC
*   165: 9B      SUB R11
*   166: 14 6A   JCN AZ, K047
*   168: 43 FA   JUN FAIL
*   16A: DF      LDM 15
*   16B: B1      XCH R1
*   16C: DF      LDM 15
*   16D: F1      CLC
*   16E: 81      ADD R1
*   16F: 12 73   JCN C1, K048
*   171: 43 FA   JUN FAIL
*   173: BB      XCH R11
*   174: DE      LDM 14
*   175: F1      CLC
*   176: 9B      SUB R11
*   177: 14 7B   JCN AZ, K049
*   179: 43 FA   JUN FAIL
*   17B: D3      LDM 3
*   17C: BD      XCH R13
*   17D: 54 03   JMS SHOW
*   17F: D0      LDM 0
*   180: B0      XCH R0
*   181: D1      LDM 1
*   182: B1      XCH R1
*   183: D2      LDM 2
*   184: B2      XCH R2
*   185: D3      LDM 3
*   186: B3      XCH R3
*   187: D4      LDM 4
*   188: B4      XCH R4
*   189: D5      LDM 5
*   18A: B5      XCH R5
*   18B: D6      LDM 6
*   18C: B6      XCH R6
*   18D: D7      LDM 7
*   18E: B7      XCH R7
*   18F: D8      LDM 8
*   190: B8      XCH R8
*   191: D9      LDM 9
*   192: B9      XCH R9
*   193: DA      LDM 10
*   194: BA      XCH R10
*   195: DB      LDM 11
*   196: BB      XCH R11
*   197: DC      LDM 12
*   198: BC      XCH R12
*   199: DD      LDM 13
*   19A: BD      XCH R13
*   19B: DE      LDM 14
*   19C: BE      XCH R14
*   19D: DF      LDM 15
*   19E: BF      XCH R15
*   19F: F1      CLC
*   1A0: D0      LDM 0
*   1A1: 90      SUB R0
*   1A2: 14 A6   JCN AZ, K050
*   1A4: 43 F8   JUN REGFAIL
*   1A6: F1      CLC
*   1A7: D1      LDM 1
*   1A8: 91      SUB R1
*   1A9: 14 AD   JCN AZ, K051
*   1AB: 43 F8   JUN REGFAIL
*   1AD: F1      CLC
*   1AE: D2      LDM 2
*   1AF: 92      SUB R2
*   1B0: 14 B4   JCN AZ, K052
*   1B2: 43 F8   JUN REGFAIL
*   1B4: F1      CLC
*   1B5: D3      LDM 3
*   1B6: 93      SUB R3
*   1B7: 14 BB   JCN AZ, K053
*   1B9: 43 F8   JUN REGFAIL
*   1BB: F1      CLC
*   1BC: D4      LDM 4
*   1BD: 94      SUB R4
*   1BE: 14 C2   JCN AZ, K054
*   1C0: 43 F8   JUN REGFAIL
*   1C2: F1      CLC
*   1C3: D5      LDM 5
*   1C4: 95      SUB R5
*   1C5: 14 C9   JCN AZ, K055
*   1C7: 43 F8   JUN REGFAIL
*   1C9: F1      CLC
*   1CA: D6      LDM 6
*   1CB: 96      SUB R6
*   1CC: 14 D0   JCN AZ, K056
*   1CE: 43 F8   JUN REGFAIL
*   1D0: F1      CLC
*   1D1: D7      LDM 7
*   1D2: 97      SUB R7
*   1D3: 14 D7   JCN AZ, K057
*   1D5: 43 F8   JUN REGFAIL
*   1D7: F1      CLC
*   1D8: D8      LDM 8
*   1D9: 98      SUB R8
*   1DA: 14 DE   JCN AZ, K058
*   1DC: 43 F8   JUN REGFAIL
*   1DE: F1      CLC
*   1DF: D9      LDM 9
*   1E0: 99      SUB R9
*   1E1: 14 E5   JCN AZ, K059
*   1E3: 43 F8   JUN REGFAIL
*   1E5: F1      CLC
*   1E6: DA      LDM 10
*   1E7: 9A      SUB R10
*   1E8: 14 EC   JCN AZ, K060
*   1EA: 43 F8   JUN REGFAIL
*   1EC: F1      CLC
*   1ED: DB      LDM 11
*   1EE: 9B      SUB R11
*   1EF: 14 F3   JCN AZ, K061
*   1F1: 43 F8   JUN REGFAIL
*   1F3: F1      CLC
*   1F4: DC      LDM 12
*   1F5: 9C      SUB R12
*   1F6: 14 FA   JCN AZ, K062
*   1F8: 43 F8   JUN REGFAIL
*   1FA: F1      CLC
*   1FB: DD      LDM 13
*   1FC: 9D      SUB R13
*   1FD: 00      NOP
*   1FE: 14 02   JCN AZ, K063
*   200: 43 F8   JUN REGFAIL
*   202: F1      CLC
*   203: DE      LDM 14
*   204: 9E      SUB R14
*   205: 14 09   JCN AZ, K064
*   207: 43 F8   JUN REGFAIL
*   209: F1      CLC
*   20A: DF      LDM 15
*   20B: 9F      SUB R15
*   20C: 14 10   JCN AZ, K065
*   20E: 43 F8   JUN REGFAIL
*   210: DF      LDM 15
*   211: B0      XCH R0
*   212: DE      LDM 14
*   213: B1      XCH R1
*   214: DD      LDM 13
*   215: B2      XCH R2
*   216: DC      LDM 12
*   217: B3      XCH R3
*   218: DB      LDM 11
*   219: B4      XCH R4
*   21A: DA      LDM 10
*   21B: B5      XCH R5
*   21C: D9      LDM 9
*   21D: B6      XCH R6
*   21E: D8      LDM 8
*   21F: B7      XCH R7
*   220: D7      LDM 7
*   221: B8      XCH R8
*   222: D6      LDM 6
*   223: B9      XCH R9
*   224: D5      LDM 5
*   225: BA      XCH R10
*   226: D4      LDM 4
*   227: BB      XCH R11
*   228: D3      LDM 3
*   229: BC      XCH R12
*   22A: D2      LDM 2
*   22B: BD      XCH R13
*   22C: D1      LDM 1
*   22D: BE      XCH R14
*   22E: D0      LDM 0
*   22F: BF      XCH R15
*   230: F1      CLC
*   231: DF      LDM 15
*   232: 90      SUB R0
*   233: 14 37   JCN AZ, K066
*   235: 43 F8   JUN REGFAIL
*   237: F1      CLC
*   238: DE      LDM 14
*   239: 91      SUB R1
*   23A: 14 3E   JCN AZ, K067
*   23C: 43 F8   JUN REGFAIL
*   23E: F1      CLC
*   23F: DD      LDM 13
*   240: 92      SUB R2
*   241: 14 45   JCN AZ, K068
*   243: 43 F8   JUN REGFAIL
*   245: F1      CLC
*   246: DC      LDM 12
*   247: 93      SUB R3
*   248: 14 4C   JCN AZ, K069
*   24A: 43 F8   JUN REGFAIL
*   24C: F1      CLC
*   24D: DB      LDM 11
*   24E: 94      SUB R4
*   24F: 14 53   JCN AZ, K070
*   251: 43 F8   JUN REGFAIL
*   253: F1      CLC
*   254: DA      LDM 10
*   255: 95      SUB R5
*   256: 14 5A   JCN AZ, K071
*   258: 43 F8   JUN REGFAIL
*   25A: F1      CLC
*   25B: D9      LDM 9
*   25C: 96      SUB R6
*   25D: 14 61   JCN AZ, K072
*   25F: 43 F8   JUN REGFAIL
*   261: F1      CLC
*   262: D8      LDM 8
*   263: 97      SUB R7
*   264: 14 68   JCN AZ, K073
*   266: 43 F8   JUN REGFAIL
*   268: F1      CLC
*   269: D7      LDM 7
*   26A: 98      SUB R8
*   26B: 14 6F   JCN AZ, K074
*   26D: 43 F8   JUN REGFAIL
*   26F: F1      CLC
*   270: D6      LDM 6
*   271: 99      SUB R9
*   272: 14 76   JCN AZ, K075
*   274: 43 F8   JUN REGFAIL
*   276: F1      CLC
*   277: D5      LDM 5
*   278: 9A      SUB R10
*   279: 14 7D   JCN AZ, K076
*   27B: 43 F8   JUN REGFAIL
*   27D: F1      CLC
*   27E: D4      LDM 4
*   27F: 9B      SUB R11
*   280: 14 84   JCN AZ, K077
*   282: 43 F8   JUN REGFAIL
*   284: F1      CLC
*   285: D3      LDM 3
*   286: 9C      SUB R12
*   287: 14 8B   JCN AZ, K078
*   289: 43 F8   JUN REGFAIL
*   28B: F1      CLC
*   28C: D2      LDM 2
*   28D: 9D      SUB R13
*   28E: 14 92   JCN AZ, K079
*   290: 43 F8   JUN REGFAIL
*   292: F1      CLC
*   293: D1      LDM 1
*   294: 9E      SUB R14
*   295: 14 99   JCN AZ, K080
*   297: 43 F8   JUN REGFAIL
*   299: F1      CLC
*   29A: D0      LDM 0
*   29B: 9F      SUB R15
*   29C: 14 A0   JCN AZ, K081
*   29E: 43 F8   JUN REGFAIL
*   2A0: D4      LDM 4
*   2A1: BD      XCH R13
*   2A2: 54 03   JMS SHOW
*   2A4: 20 5A   FIM P0, 0x5A
*   2A6: F1      CLC
*   2A7: D5      LDM 5
*   2A8: 90      SUB R0
*   2A9: 14 AD   JCN AZ, K082
*   2AB: 43 FA   JUN FAIL
*   2AD: F1      CLC
*   2AE: DA      LDM 10
*   2AF: 91      SUB R1
*   2B0: 14 B4   JCN AZ, K083
*   2B2: 43 FA   JUN FAIL
*   2B4: D3      LDM 3
*   2B5: B0      XCH R0
*   2B6: BB      XCH R11
*   2B7: D5      LDM 5
*   2B8: F1      CLC
*   2B9: 9B      SUB R11
*   2BA: 14 BE   JCN AZ, K084
*   2BC: 43 FA   JUN FAIL
*   2BE: F1      CLC
*   2BF: D3      LDM 3
*   2C0: 90      SUB R0
*   2C1: 14 C5   JCN AZ, K085
*   2C3: 43 FA   JUN FAIL
*   2C5: DF      LDM 15
*   2C6: B2      XCH R2
*   2C7: 62      INC R2
*   2C8: A2      LD R2
*   2C9: BB      XCH R11
*   2CA: D0      LDM 0
*   2CB: F1      CLC
*   2CC: 9B      SUB R11
*   2CD: 14 D1   JCN AZ, K086
*   2CF: 43 FA   JUN FAIL
*   2D1: DC      LDM 12
*   2D2: B2      XCH R2
*   2D3: D0      LDM 0
*   2D4: B3      XCH R3
*   2D5: 63      INC R3
*   2D6: 72 D5   ISZ R2, T4LP
*   2D8: A3      LD R3
*   2D9: BB      XCH R11
*   2DA: D4      LDM 4
*   2DB: F1      CLC
*   2DC: 9B      SUB R11
*   2DD: 14 E1   JCN AZ, K087
*   2DF: 43 FA   JUN FAIL
*   2E1: 20 F7   FIM P0, TBL & 0xFF
*   2E3: 32      FIN P1
*   2E4: F1      CLC
*   2E5: DC      LDM 12
*   2E6: 92      SUB R2
*   2E7: 14 EB   JCN AZ, K088
*   2E9: 43 FA   JUN FAIL
*   2EB: F1      CLC
*   2EC: D3      LDM 3
*   2ED: 93      SUB R3
*   2EE: 14 F2   JCN AZ, K089
*   2F0: 43 FA   JUN FAIL
*   2F2: 24 F8   FIM P2, T4JT & 0xFF
*   2F4: 35      JIN P2
*   2F5: 43 FA   JUN FAIL
*   2F7: C3      DB 0xC3
*   2F8: D5      LDM 5
*   2F9: BD      XCH R13
*   2FA: 54 03   JMS SHOW
*   2FC: D0      LDM 0
*   2FD: B4      XCH R4
*   2FE: 53 13   JMS SUB1
*   300: BB      XCH R11
*   301: D7      LDM 7
*   302: F1      CLC
*   303: 9B      SUB R11
*   304: 14 08   JCN AZ, K090
*   306: 43 FA   JUN FAIL
*   308: A4      LD R4
*   309: BB      XCH R11
*   30A: D3      LDM 3
*   30B: F1      CLC
*   30C: 9B      SUB R11
*   30D: 14 11   JCN AZ, K091
*   30F: 43 FA   JUN FAIL
*   311: 43 2D   JUN T6
*   313: 64      INC R4
*   314: 53 1F   JMS SUB2
*   316: BB      XCH R11
*   317: D6      LDM 6
*   318: F1      CLC
*   319: 9B      SUB R11
*   31A: 14 1E   JCN AZ, K092
*   31C: 43 FA   JUN FAIL
*   31E: C7      BBL 7
*   31F: 64      INC R4
*   320: 53 2B   JMS SUB3
*   322: BB      XCH R11
*   323: D5      LDM 5
*   324: F1      CLC
*   325: 9B      SUB R11
*   326: 14 2A   JCN AZ, K093
*   328: 43 FA   JUN FAIL
*   32A: C6      BBL 6
*   32B: 64      INC R4
*   32C: C5      BBL 5
*   32D: D6      LDM 6
*   32E: BD      XCH R13
*   32F: 54 03   JMS SHOW
*   331: D0      LDM 0
*   332: 14 36   JCN AZ, T6A
*   334: 43 FA   JUN FAIL
*   336: D1      LDM 1
*   337: 1C 3B   JCN AN, T6B
*   339: 43 FA   JUN FAIL
*   33B: FA      STC
*   33C: 12 40   JCN C1, T6C
*   33E: 43 FA   JUN FAIL
*   340: F1      CLC
*   341: 1A 45   JCN C0, T6D
*   343: 43 FA   JUN FAIL
*   345: D1      LDM 1
*   346: FA      STC
*   347: 16 4B   JCN AZC1, T6E
*   349: 43 FA   JUN FAIL
*   34B: D1      LDM 1
*   34C: F1      CLC
*   34D: 1E 51   JCN NAZC1, T6G
*   34F: 43 FA   JUN FAIL
*   351: D1      LDM 1
*   352: 14 67   JCN AZ, T6F
*   354: D0      LDM 0
*   355: 1C 67   JCN AN, T6F
*   357: F1      CLC
*   358: 12 67   JCN C1, T6F
*   35A: FA      STC
*   35B: 1A 67   JCN C0, T6F
*   35D: D1      LDM 1
*   35E: F1      CLC
*   35F: 16 67   JCN AZC1, T6F
*   361: D0      LDM 0
*   362: F1      CLC
*   363: 1E 67   JCN NAZC1, T6F
*   365: 43 69   JUN T7
*   367: 43 FA   JUN FAIL
*   369: D7      LDM 7
*   36A: BD      XCH R13
*   36B: 54 03   JMS SHOW
*   36D: 20 00   FIM P0, 0x00
*   36F: 21      SRC P0
*   370: D6      LDM 6
*   371: E0      WRM
*   372: D3      LDM 3
*   373: F1      CLC
*   374: EB      ADM
*   375: 1A 79   JCN C0, K094
*   377: 43 FA   JUN FAIL
*   379: BB      XCH R11
*   37A: D9      LDM 9
*   37B: F1      CLC
*   37C: 9B      SUB R11
*   37D: 14 81   JCN AZ, K095
*   37F: 43 FA   JUN FAIL
*   381: D9      LDM 9
*   382: F1      CLC
*   383: E8      SBM
*   384: 12 88   JCN C1, K096
*   386: 43 FA   JUN FAIL
*   388: BB      XCH R11
*   389: D3      LDM 3
*   38A: F1      CLC
*   38B: 9B      SUB R11
*   38C: 14 90   JCN AZ, K097
*   38E: 43 FA   JUN FAIL
*   390: D0      LDM 0
*   391: B4      XCH R4
*   392: 20 00   FIM P0, 0x00
*   394: DC      LDM 12
*   395: B2      XCH R2
*   396: 21      SRC P0
*   397: 54 09   JMS PAT
*   399: A3      LD R3
*   39A: E0      WRM
*   39B: 71 96   ISZ R1, T7W
*   39D: A0      LD R0
*   39E: E4      WR0
*   39F: F4      CMA
*   3A0: E5      WR1
*   3A1: D8      LDM 8
*   3A2: F1      CLC
*   3A3: 80      ADD R0
*   3A4: E6      WR2
*   3A5: F4      CMA
*   3A6: E7      WR3
*   3A7: 60      INC R0
*   3A8: 72 96   ISZ R2, T7W
*   3AA: 20 00   FIM P0, 0x00
*   3AC: DC      LDM 12
*   3AD: B2      XCH R2
*   3AE: 21      SRC P0
*   3AF: 54 09   JMS PAT
*   3B1: E9      RDM
*   3B2: F1      CLC
*   3B3: 93      SUB R3
*   3B4: 14 B8   JCN AZ, K098
*   3B6: 43 FA   JUN FAIL
*   3B8: 71 AE   ISZ R1, T7R
*   3BA: EC      RD0
*   3BB: F1      CLC
*   3BC: 90      SUB R0
*   3BD: 14 C1   JCN AZ, K099
*   3BF: 43 FA   JUN FAIL
*   3C1: ED      RD1
*   3C2: F4      CMA
*   3C3: F1      CLC
*   3C4: 90      SUB R0
*   3C5: 14 C9   JCN AZ, K100
*   3C7: 43 FA   JUN FAIL
*   3C9: D8      LDM 8
*   3CA: F1      CLC
*   3CB: 80      ADD R0
*   3CC: B3      XCH R3
*   3CD: EE      RD2
*   3CE: F1      CLC
*   3CF: 93      SUB R3
*   3D0: 14 D4   JCN AZ, K101
*   3D2: 43 FA   JUN FAIL
*   3D4: EF      RD3
*   3D5: F4      CMA
*   3D6: F1      CLC
*   3D7: 93      SUB R3
*   3D8: 14 DC   JCN AZ, K102
*   3DA: 43 FA   JUN FAIL
*   3DC: 60      INC R0
*   3DD: 72 AE   ISZ R2, T7R
*   3DF: A4      LD R4
*   3E0: 1C E5   JCN AN, PASS
*   3E2: 64      INC R4
*   3E3: 43 92   JUN T7P
*   3E5: 2E 00   FIM P7, 0x00
*   3E7: 2F      SRC P7
*   3E8: D1      LDM 1
*   3E9: E1      WMP
*   3EA: DC      LDM 12
*   3EB: BC      XCH R12
*   3EC: DA      LDM 10
*   3ED: E2      WRR
*   3EE: 54 14   JMS DELAY
*   3F0: D5      LDM 5
*   3F1: E2      WRR
*   3F2: 54 14   JMS DELAY
*   3F4: 7C EC   ISZ R12, BLINK
*   3F6: 40 08   JUN T1
*   3F8: D3      LDM 3
*   3F9: BD      XCH R13
*   3FA: 2E 00   FIM P7, 0x00
*   3FC: 2F      SRC P7
*   3FD: AD      LD R13
*   3FE: E2      WRR
*   3FF: DF      LDM 15
*   400: E1      WMP
*   401: 44 01   JUN HALT
*   403: 2E 00   FIM P7, 0x00
*   405: 2F      SRC P7
*   406: AD      LD R13
*   407: E2      WRR
*   408: C0      BBL 0
*   409: A1      LD R1
*   40A: F1      CLC
*   40B: 80      ADD R0
*   40C: B3      XCH R3
*   40D: A4      LD R4
*   40E: 14 13   JCN AZ, PAT1
*   410: A3      LD R3
*   411: F4      CMA
*   412: B3      XCH R3
*   413: C0      BBL 0
*   414: 20 00   FIM P0, 0x00
*   416: 22 08   FIM P1, 0x08
*   418: 70 18   ISZ R0, DLY
*   41A: 71 18   ISZ R1, DLY
*   41C: 72 18   ISZ R2, DLY
*   41E: 73 18   ISZ R3, DLY
*   420: C0      BBL 0
*
*  Expected WRR (ROM port 0) outputs, bus value during X2:
*   period   70: port <-  0 (0000)
*   period  142: port <-  1 (0001)
*
*  Output-port writes expected from the ISA model (instruction cycle: value):
*   cycle      6: WMP RAM bank 0 chip 0 <- 0
*   cycle      7: WRR ROM port 0 <- 0
*   cycle     16: WRR ROM port 0 <- 1

.save v(d0) v(d1) v(d2) v(d3) v(sync) v(cmrom) v(cmram0) v(cmram1) v(cmram2) v(cmram3) v(phi1) v(phi2) v(reset) v(busval) v(rport) v(mport) i(vvdd)
.tran {TCLK/40} {TSTOP} 0 {TCLK/40}
.options klu
.control
pre_osdi mcs4mem.osdi
run
meas tran port_out1 FIND v(rport) AT=9.652500e-05
meas tran port_out2 FIND v(rport) AT=1.937250e-04
meas tran idd_avg AVG i(vvdd) FROM=1.0800e-05 TO=2.268000e-04
write i4004_pmos_va.raw v(d0) v(d1) v(d2) v(d3) v(sync) v(cmrom) v(cmram0) v(cmram1) v(cmram2) v(cmram3) v(phi1) v(phi2) v(reset) v(rport) v(mport) v(busval) i(vvdd)
.endc
.end
